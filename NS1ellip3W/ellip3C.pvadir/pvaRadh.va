// pvaRad.va : PVADB_VERSION 00.20
//     Written by pva on Sun Sep 14 19:03:59 2025
// path: Z:\SIdesign\NS1ellip3W

// file "C:/synopsys/Hspice_S-2021.09/include/std.va", line 28
nature Current
    units = "A";
    access = I;
    idt_nature = Charge;
    abstol = 1e-12;
endnature

// file "C:/synopsys/Hspice_S-2021.09/include/std.va", line 39
nature Charge
    units = "coul";
    access = Q;
    ddt_nature = Current;
    abstol = 1e-14;
endnature

// file "C:/synopsys/Hspice_S-2021.09/include/std.va", line 50
nature Voltage
    units = "V";
    access = V;
    idt_nature = Flux;
    abstol = 1e-06;
endnature

// file "C:/synopsys/Hspice_S-2021.09/include/std.va", line 61
nature Flux
    units = "Wb";
    access = Phi;
    ddt_nature = Voltage;
    abstol = 1e-09;
endnature

// file "C:/synopsys/Hspice_S-2021.09/include/std.va", line 86
nature Magneto_Motive_Force
    units = "A*turn";
    access = MMF;
    abstol = 1e-12;
endnature

// file "C:/synopsys/Hspice_S-2021.09/include/std.va", line 102
nature Temperature
    units = "K";
    access = Temp;
    abstol = 0.0001;
endnature

// file "C:/synopsys/Hspice_S-2021.09/include/std.va", line 112
nature Power
    units = "W";
    access = Pwr;
    abstol = 1e-09;
endnature

// file "C:/synopsys/Hspice_S-2021.09/include/std.va", line 129
nature Position
    units = "m";
    access = Pos;
    ddt_nature = Velocity;
    abstol = 1e-06;
endnature

// file "C:/synopsys/Hspice_S-2021.09/include/std.va", line 140
nature Velocity
    units = "m/s";
    access = Vel;
    ddt_nature = Acceleration;
    idt_nature = Position;
    abstol = 1e-06;
endnature

// file "C:/synopsys/Hspice_S-2021.09/include/std.va", line 152
nature Acceleration
    units = "m/s^2";
    access = Acc;
    ddt_nature = Impulse;
    idt_nature = Velocity;
    abstol = 1e-06;
endnature

// file "C:/synopsys/Hspice_S-2021.09/include/std.va", line 164
nature Impulse
    units = "m/s^3";
    access = Imp;
    idt_nature = Acceleration;
    abstol = 1e-06;
endnature

// file "C:/synopsys/Hspice_S-2021.09/include/std.va", line 175
nature Force
    units = "N";
    access = F;
    abstol = 1e-06;
endnature

// file "C:/synopsys/Hspice_S-2021.09/include/std.va", line 195
nature Angle
    units = "rads";
    access = Theta;
    ddt_nature = Angular_Velocity;
    abstol = 1e-06;
endnature

// file "C:/synopsys/Hspice_S-2021.09/include/std.va", line 206
nature Angular_Velocity
    units = "rads/s";
    access = Omega;
    ddt_nature = Angular_Acceleration;
    idt_nature = Angle;
    abstol = 1e-06;
endnature

// file "C:/synopsys/Hspice_S-2021.09/include/std.va", line 218
nature Angular_Acceleration
    units = "rads/s^2";
    access = Alpha;
    idt_nature = Angular_Velocity;
    abstol = 1e-06;
endnature

// file "C:/synopsys/Hspice_S-2021.09/include/std.va", line 229
nature Angular_Force
    units = "N*m";
    access = Tau;
    abstol = 1e-06;
endnature

// file "C:/synopsys/Hspice_S-2021.09/include/std.va", line 16
discipline logic
    domain discrete;
enddiscipline

// file "C:/synopsys/Hspice_S-2021.09/include/std.va", line 20
discipline logical
    domain discrete;
enddiscipline

// file "C:/synopsys/Hspice_S-2021.09/include/std.va", line 75
discipline electrical
    potential Voltage;
    flow Current;
enddiscipline

// file "C:/synopsys/Hspice_S-2021.09/include/std.va", line 79
discipline voltage
    potential Voltage;
enddiscipline

// file "C:/synopsys/Hspice_S-2021.09/include/std.va", line 82
discipline current
    potential Current;
enddiscipline

// file "C:/synopsys/Hspice_S-2021.09/include/std.va", line 99
discipline magnetic
    potential Magneto_Motive_Force;
    flow Flux;
enddiscipline

// file "C:/synopsys/Hspice_S-2021.09/include/std.va", line 125
discipline thermal
    potential Temperature;
    flow Power;
enddiscipline

// file "C:/synopsys/Hspice_S-2021.09/include/std.va", line 188
discipline kinematic
    potential Position;
    flow Force;
enddiscipline

// file "C:/synopsys/Hspice_S-2021.09/include/std.va", line 192
discipline kinematic_v
    potential Velocity;
    flow Force;
enddiscipline

// file "C:/synopsys/Hspice_S-2021.09/include/std.va", line 242
discipline rotational
    potential Angle;
    flow Angular_Force;
enddiscipline

// file "C:/synopsys/Hspice_S-2021.09/include/std.va", line 246
discipline rotational_omega
    potential Angular_Velocity;
    flow Angular_Force;
enddiscipline

// file "Z:/SIdesign/NS1ellip3W//source/bsimcmg_body.include", line 83
module bsimcmg (d, g, s, e, t);

// file "Z:/SIdesign/NS1ellip3W//source/bsimcmg_body.include", line 84
inout g, d, s, e, t;

// file "Z:/SIdesign/NS1ellip3W//source/bsimcmg_body.include", line 85
electrical g, d, s, e;

// file "Z:/SIdesign/NS1ellip3W//source/bsimcmg_body.include", line 86
electrical si, di;

// file "Z:/SIdesign/NS1ellip3W//source/bsimcmg_body.include", line 97
electrical ge;

// file "Z:/SIdesign/NS1ellip3W//source/bsimcmg_body.include", line 101
thermal t;

// file "Z:/SIdesign/NS1ellip3W//source/bsimcmg_body.include", line 102
branch (t) rth_branch;

// file "Z:/SIdesign/NS1ellip3W//source/bsimcmg_body.include", line 103
branch (t) ith_branch;

// file "Z:/SIdesign/NS1ellip3W//source/bsimcmg_body.include", line 110
electrical N;
function real lexp;
input x;
real x;

begin
    if (x > 80.0) begin
        lexp = 5.540622384000e+34 * (1.0 + x - 80.0);
    end
    else if (x < -80.0) begin
        lexp = 1.804851387e-35;
    end
    else begin
        lexp = exp(x);
    end
end
endfunction

function real lln;
input x;
real x;

begin
    lln = ln(max(x,9.9999999999999996e-39));
end
endfunction

function real hypsmooth;
input x, c;
real x, c;

begin
    hypsmooth = 0.5 * (x + sqrt(x * x + 4.0 * c * c));
end
endfunction

function real hypmax;
input x, xmin, c;
real x, xmin, c;

begin
    hypmax = xmin + 0.5 * (x - xmin - c + sqrt((x - xmin - c) * (x - xmin - c) - 4.0 * xmin * c));
end
endfunction

function real Tempdep;
input PARAML, PARAMT, DELTEMP, TEMPMOD;
real PARAML, PARAMT, DELTEMP, TEMPMOD;

begin
    if (TEMPMOD != 0) begin
        Tempdep = PARAML + hypmax(PARAMT * DELTEMP,-PARAML,1e-06);
    end
    else begin
        Tempdep = PARAML * hypsmooth(1.0 + PARAMT * DELTEMP - 1e-06,0.001);
    end
end
endfunction

// file "Z:/SIdesign/NS1ellip3W//source/bsimcmg_body.include", line 121
parameter real L = 3e-08 from [1e-09:inf);

// file "Z:/SIdesign/NS1ellip3W//source/bsimcmg_body.include", line 122
parameter real D = 4e-08 from [1e-09:inf);

// file "Z:/SIdesign/NS1ellip3W//source/bsimcmg_body.include", line 123
parameter real TFIN = 1.5e-08 from [1e-09:inf);

// file "Z:/SIdesign/NS1ellip3W//source/bsimcmg_body.include", line 124
parameter real FPITCH = 8e-08 from [TFIN:inf);

// file "Z:/SIdesign/NS1ellip3W//source/bsimcmg_body.include", line 125
parameter integer NF = 1 from [1:inf);

// file "Z:/SIdesign/NS1ellip3W//source/bsimcmg_body.include", line 126
parameter real NFIN = 1.0 from (0:inf);

// file "Z:/SIdesign/NS1ellip3W//source/bsimcmg_body.include", line 127
parameter integer NGCON = 1 from [1:2];

// file "Z:/SIdesign/NS1ellip3W//source/bsimcmg_body.include", line 128
parameter real ASEO = 0.0 from [0:inf);

// file "Z:/SIdesign/NS1ellip3W//source/bsimcmg_body.include", line 129
parameter real ADEO = 0.0 from [0:inf);

// file "Z:/SIdesign/NS1ellip3W//source/bsimcmg_body.include", line 130
parameter real PSEO = 0.0 from [0:inf);

// file "Z:/SIdesign/NS1ellip3W//source/bsimcmg_body.include", line 131
parameter real PDEO = 0.0 from [0:inf);

// file "Z:/SIdesign/NS1ellip3W//source/bsimcmg_body.include", line 132
parameter real ASEJ = 0.0 from [0:inf);

// file "Z:/SIdesign/NS1ellip3W//source/bsimcmg_body.include", line 133
parameter real ADEJ = 0.0 from [0:inf);

// file "Z:/SIdesign/NS1ellip3W//source/bsimcmg_body.include", line 134
parameter real PSEJ = 0.0 from [0:inf);

// file "Z:/SIdesign/NS1ellip3W//source/bsimcmg_body.include", line 135
parameter real PDEJ = 0.0 from [0:inf);

// file "Z:/SIdesign/NS1ellip3W//source/bsimcmg_body.include", line 136
parameter real COVS = 0.0 from [0:inf);

// file "Z:/SIdesign/NS1ellip3W//source/bsimcmg_body.include", line 137
parameter real COVD = COVS from [0:inf);

// file "Z:/SIdesign/NS1ellip3W//source/bsimcmg_body.include", line 138
parameter real CGSP = 0.0 from [0:inf);

// file "Z:/SIdesign/NS1ellip3W//source/bsimcmg_body.include", line 139
parameter real CGDP = 0.0 from [0:inf);

// file "Z:/SIdesign/NS1ellip3W//source/bsimcmg_body.include", line 140
parameter real CDSP = 0.0 from [0:inf);

// file "Z:/SIdesign/NS1ellip3W//source/bsimcmg_body.include", line 141
parameter real NRS = 0.0 from [0:inf);

// file "Z:/SIdesign/NS1ellip3W//source/bsimcmg_body.include", line 142
parameter real NRD = 0.0 from [0:inf);

// file "Z:/SIdesign/NS1ellip3W//source/bsimcmg_body.include", line 143
parameter real LRSD = L from (0:inf);

// file "Z:/SIdesign/NS1ellip3W//source/bsimcmg_body.include", line 144
parameter real NFINNOM = 1.0 from (0:inf);

// file "Z:/SIdesign/NS1ellip3W//source/bsimcmg_body.include", line 147
parameter real XL = 0.0;

// file "Z:/SIdesign/NS1ellip3W//source/bsimcmg_body.include", line 148
parameter real DTEMP = 0.0;

// file "Z:/SIdesign/NS1ellip3W//source/bsimcmg_body.include", line 149
parameter real DELVTRAND = 0.0;

// file "Z:/SIdesign/NS1ellip3W//source/bsimcmg_body.include", line 150
parameter real U0MULT = 1.0 from [0:inf);

// file "Z:/SIdesign/NS1ellip3W//source/bsimcmg_body.include", line 151
parameter real IDS0MULT = 1.0 from [0:inf);

// file "Z:/SIdesign/NS1ellip3W//source/bsimcmg_body.include", line 156
parameter integer DEVTYPE = 1 from [0:1];

// file "Z:/SIdesign/NS1ellip3W//source/bsimcmg_body.include", line 157
parameter integer TYPE = DEVTYPE from [0:1];

// file "Z:/SIdesign/NS1ellip3W//source/bsimcmg_body.include", line 158
parameter integer BULKMOD = 0 from [0:2];

// file "Z:/SIdesign/NS1ellip3W//source/bsimcmg_body.include", line 159
parameter integer GEOMOD = 0 from [0:4];

// file "Z:/SIdesign/NS1ellip3W//source/bsimcmg_body.include", line 160
parameter integer CGEO1SW = 0 from [0:1];

// file "Z:/SIdesign/NS1ellip3W//source/bsimcmg_body.include", line 161
parameter integer RDSMOD = 0 from [0:2];

// file "Z:/SIdesign/NS1ellip3W//source/bsimcmg_body.include", line 162
parameter integer ASYMMOD = 0 from [0:1];

// file "Z:/SIdesign/NS1ellip3W//source/bsimcmg_body.include", line 163
parameter integer IGCMOD = 0 from [0:1];

// file "Z:/SIdesign/NS1ellip3W//source/bsimcmg_body.include", line 164
parameter integer IGBMOD = 0 from [0:1];

// file "Z:/SIdesign/NS1ellip3W//source/bsimcmg_body.include", line 165
parameter integer GIDLMOD = 0 from [0:1];

// file "Z:/SIdesign/NS1ellip3W//source/bsimcmg_body.include", line 166
parameter integer IIMOD = 0 from [0:2];

// file "Z:/SIdesign/NS1ellip3W//source/bsimcmg_body.include", line 167
parameter integer TNOIMOD = 0 from [0:1];

// file "Z:/SIdesign/NS1ellip3W//source/bsimcmg_body.include", line 168
parameter integer NQSMOD = 0 from [0:2];

// file "Z:/SIdesign/NS1ellip3W//source/bsimcmg_body.include", line 169
parameter integer SHMOD = 0 from [0:1];

// file "Z:/SIdesign/NS1ellip3W//source/bsimcmg_body.include", line 170
parameter integer TEMPMOD = 0 from [0:1];

// file "Z:/SIdesign/NS1ellip3W//source/bsimcmg_body.include", line 171
parameter integer RGATEMOD = 0 from [0:1];

// file "Z:/SIdesign/NS1ellip3W//source/bsimcmg_body.include", line 172
parameter integer RGEOMOD = 0 from [0:1];

// file "Z:/SIdesign/NS1ellip3W//source/bsimcmg_body.include", line 173
parameter integer CGEOMOD = 0 from [0:2];

// file "Z:/SIdesign/NS1ellip3W//source/bsimcmg_body.include", line 174
parameter integer SH_WARN = 0 from [0:1];

// file "Z:/SIdesign/NS1ellip3W//source/bsimcmg_body.include", line 175
parameter integer IGCLAMP = 1 from [0:1];

// file "Z:/SIdesign/NS1ellip3W//source/bsimcmg_body.include", line 176
parameter real LINT = 0.0;

// file "Z:/SIdesign/NS1ellip3W//source/bsimcmg_body.include", line 177
parameter real LL = 0.0;

// file "Z:/SIdesign/NS1ellip3W//source/bsimcmg_body.include", line 178
parameter real LLN = 1.0;

// file "Z:/SIdesign/NS1ellip3W//source/bsimcmg_body.include", line 179
parameter real DLC = 0.0;

// file "Z:/SIdesign/NS1ellip3W//source/bsimcmg_body.include", line 180
parameter real DLCACC = 0.0;

// file "Z:/SIdesign/NS1ellip3W//source/bsimcmg_body.include", line 181
parameter real DLBIN = 0.0;

// file "Z:/SIdesign/NS1ellip3W//source/bsimcmg_body.include", line 182
parameter real LLC = 0.0;

// file "Z:/SIdesign/NS1ellip3W//source/bsimcmg_body.include", line 183
parameter real EOT = 1e-09 from [1e-10:inf);

// file "Z:/SIdesign/NS1ellip3W//source/bsimcmg_body.include", line 184
parameter real TOXP = 1.2e-09 from [1e-10:inf);

// file "Z:/SIdesign/NS1ellip3W//source/bsimcmg_body.include", line 185
parameter real EOTBOX = 1.4e-07 from [1e-09:inf);

// file "Z:/SIdesign/NS1ellip3W//source/bsimcmg_body.include", line 186
parameter real HFIN = 3e-08 from [1e-09:inf);

// file "Z:/SIdesign/NS1ellip3W//source/bsimcmg_body.include", line 187
parameter real FECH = 1.0 from [0:inf);

// file "Z:/SIdesign/NS1ellip3W//source/bsimcmg_body.include", line 188
parameter real DELTAW = 0.0;

// file "Z:/SIdesign/NS1ellip3W//source/bsimcmg_body.include", line 189
parameter real FECHCV = 1.0 from [0:inf);

// file "Z:/SIdesign/NS1ellip3W//source/bsimcmg_body.include", line 190
parameter real DELTAWCV = 0.0;

// file "Z:/SIdesign/NS1ellip3W//source/bsimcmg_body.include", line 191
parameter real NBODY = 1.000000000000e+22;

// file "Z:/SIdesign/NS1ellip3W//source/bsimcmg_body.include", line 192
parameter real NBODYN1 = 0.0;

// file "Z:/SIdesign/NS1ellip3W//source/bsimcmg_body.include", line 193
parameter real NBODYN2 = 100000.0 exclude 0.0;

// file "Z:/SIdesign/NS1ellip3W//source/bsimcmg_body.include", line 194
parameter real NSD = 2.000000000000e+26 from [2.000000000000e+20:1.000000000000e+27];

// file "Z:/SIdesign/NS1ellip3W//source/bsimcmg_body.include", line 195
parameter real PHIG = 4.61 from [0:inf);

// file "Z:/SIdesign/NS1ellip3W//source/bsimcmg_body.include", line 196
parameter real PHIGL = 0.0;

// file "Z:/SIdesign/NS1ellip3W//source/bsimcmg_body.include", line 197
parameter real PHIGLT = 0.0;

// file "Z:/SIdesign/NS1ellip3W//source/bsimcmg_body.include", line 198
parameter real PHIGN1 = 0.0;

// file "Z:/SIdesign/NS1ellip3W//source/bsimcmg_body.include", line 199
parameter real PHIGN2 = 100000.0 exclude 0.0;

// file "Z:/SIdesign/NS1ellip3W//source/bsimcmg_body.include", line 200
parameter real EPSROX = 3.9 from [1.0:inf);

// file "Z:/SIdesign/NS1ellip3W//source/bsimcmg_body.include", line 201
parameter real EPSRSUB = 11.9 from [1.0:inf);

// file "Z:/SIdesign/NS1ellip3W//source/bsimcmg_body.include", line 202
parameter real EASUB = 4.05 from [0:inf);

// file "Z:/SIdesign/NS1ellip3W//source/bsimcmg_body.include", line 203
parameter real NI0SUB = 1.100000000000e+16;

// file "Z:/SIdesign/NS1ellip3W//source/bsimcmg_body.include", line 204
parameter real BG0SUB = 1.12;

// file "Z:/SIdesign/NS1ellip3W//source/bsimcmg_body.include", line 205
parameter real NC0SUB = 2.860000000000e+25;

// file "Z:/SIdesign/NS1ellip3W//source/bsimcmg_body.include", line 206
parameter real NGATE = 0.0;

// file "Z:/SIdesign/NS1ellip3W//source/bsimcmg_body.include", line 207
parameter real Imin = 1e-15;

// file "Z:/SIdesign/NS1ellip3W//source/bsimcmg_body.include", line 210
parameter real CIT = 0.0;

// file "Z:/SIdesign/NS1ellip3W//source/bsimcmg_body.include", line 211
parameter real CITR = CIT;

// file "Z:/SIdesign/NS1ellip3W//source/bsimcmg_body.include", line 212
parameter real CDSC = 0.007;

// file "Z:/SIdesign/NS1ellip3W//source/bsimcmg_body.include", line 213
parameter real CDSCN1 = 0.0;

// file "Z:/SIdesign/NS1ellip3W//source/bsimcmg_body.include", line 214
parameter real CDSCN2 = 100000.0;

// file "Z:/SIdesign/NS1ellip3W//source/bsimcmg_body.include", line 215
parameter real CDSCD = 0.007;

// file "Z:/SIdesign/NS1ellip3W//source/bsimcmg_body.include", line 216
parameter real CDSCDN1 = 0.0;

// file "Z:/SIdesign/NS1ellip3W//source/bsimcmg_body.include", line 217
parameter real CDSCDN2 = 100000.0 exclude 0.0;

// file "Z:/SIdesign/NS1ellip3W//source/bsimcmg_body.include", line 218
parameter real CDSCDR = CDSCD;

// file "Z:/SIdesign/NS1ellip3W//source/bsimcmg_body.include", line 219
parameter real CDSCDRN1 = CDSCDN1;

// file "Z:/SIdesign/NS1ellip3W//source/bsimcmg_body.include", line 220
parameter real CDSCDRN2 = CDSCDN2 exclude 0.0;

// file "Z:/SIdesign/NS1ellip3W//source/bsimcmg_body.include", line 221
parameter real DVT0 = 0.0;

// file "Z:/SIdesign/NS1ellip3W//source/bsimcmg_body.include", line 222
parameter real DVT1 = 0.6;

// file "Z:/SIdesign/NS1ellip3W//source/bsimcmg_body.include", line 223
parameter real DVT1SS = DVT1;

// file "Z:/SIdesign/NS1ellip3W//source/bsimcmg_body.include", line 224
parameter real PHIN = 0.05;

// file "Z:/SIdesign/NS1ellip3W//source/bsimcmg_body.include", line 225
parameter real ETA0 = 0.6;

// file "Z:/SIdesign/NS1ellip3W//source/bsimcmg_body.include", line 226
parameter real ETA0N1 = 0.0;

// file "Z:/SIdesign/NS1ellip3W//source/bsimcmg_body.include", line 227
parameter real ETA0N2 = 100000.0 from [1e-05:inf);

// file "Z:/SIdesign/NS1ellip3W//source/bsimcmg_body.include", line 228
parameter real ETA0LT = 0.0;

// file "Z:/SIdesign/NS1ellip3W//source/bsimcmg_body.include", line 229
parameter real TETA0 = 0.0;

// file "Z:/SIdesign/NS1ellip3W//source/bsimcmg_body.include", line 230
parameter real ETA0R = ETA0;

// file "Z:/SIdesign/NS1ellip3W//source/bsimcmg_body.include", line 231
parameter real TETA0R = TETA0;

// file "Z:/SIdesign/NS1ellip3W//source/bsimcmg_body.include", line 232
parameter real DSUB = 1.06;

// file "Z:/SIdesign/NS1ellip3W//source/bsimcmg_body.include", line 233
parameter real DVTP0 = 0.0;

// file "Z:/SIdesign/NS1ellip3W//source/bsimcmg_body.include", line 234
parameter real DVTP1 = 0.0;

// file "Z:/SIdesign/NS1ellip3W//source/bsimcmg_body.include", line 235
parameter real ADVTP0 = 0.0;

// file "Z:/SIdesign/NS1ellip3W//source/bsimcmg_body.include", line 236
parameter real BDVTP0 = 1e-07 exclude 0.0;

// file "Z:/SIdesign/NS1ellip3W//source/bsimcmg_body.include", line 237
parameter real ADVTP1 = 0.0;

// file "Z:/SIdesign/NS1ellip3W//source/bsimcmg_body.include", line 238
parameter real BDVTP1 = 1e-07 exclude 0.0;

// file "Z:/SIdesign/NS1ellip3W//source/bsimcmg_body.include", line 239
parameter real DVTP2 = 0.0;

// file "Z:/SIdesign/NS1ellip3W//source/bsimcmg_body.include", line 240
parameter real K1RSCE = 0.0;

// file "Z:/SIdesign/NS1ellip3W//source/bsimcmg_body.include", line 241
parameter real LPE0 = 5e-09;

// file "Z:/SIdesign/NS1ellip3W//source/bsimcmg_body.include", line 242
parameter real DVTSHIFT = 0.0;

// file "Z:/SIdesign/NS1ellip3W//source/bsimcmg_body.include", line 243
parameter real DVTSHIFTR = DVTSHIFT;

// file "Z:/SIdesign/NS1ellip3W//source/bsimcmg_body.include", line 244
parameter real THETASCE = 0.0;

// file "Z:/SIdesign/NS1ellip3W//source/bsimcmg_body.include", line 245
parameter real THETADIBL = 0.0;

// file "Z:/SIdesign/NS1ellip3W//source/bsimcmg_body.include", line 246
parameter real THETASW = 0.0;

// file "Z:/SIdesign/NS1ellip3W//source/bsimcmg_body.include", line 247
parameter real NVTM = 0.0;

// file "Z:/SIdesign/NS1ellip3W//source/bsimcmg_body.include", line 250
parameter real K0 = 0.0;

// file "Z:/SIdesign/NS1ellip3W//source/bsimcmg_body.include", line 251
parameter real K01 = 0.0;

// file "Z:/SIdesign/NS1ellip3W//source/bsimcmg_body.include", line 252
parameter real K0SI = 1.0;

// file "Z:/SIdesign/NS1ellip3W//source/bsimcmg_body.include", line 253
parameter real K0SI1 = 0.0;

// file "Z:/SIdesign/NS1ellip3W//source/bsimcmg_body.include", line 254
parameter real K2SI = K0SI;

// file "Z:/SIdesign/NS1ellip3W//source/bsimcmg_body.include", line 255
parameter real K2SI1 = K0SI1;

// file "Z:/SIdesign/NS1ellip3W//source/bsimcmg_body.include", line 256
parameter real K0SISAT = 0.0;

// file "Z:/SIdesign/NS1ellip3W//source/bsimcmg_body.include", line 257
parameter real K0SISAT1 = 0.0;

// file "Z:/SIdesign/NS1ellip3W//source/bsimcmg_body.include", line 258
parameter real K2SISAT = K0SISAT;

// file "Z:/SIdesign/NS1ellip3W//source/bsimcmg_body.include", line 259
parameter real K2SISAT1 = K0SISAT1;

// file "Z:/SIdesign/NS1ellip3W//source/bsimcmg_body.include", line 262
parameter real PHIBE = 0.7;

// file "Z:/SIdesign/NS1ellip3W//source/bsimcmg_body.include", line 263
parameter real K1 = 1e-06 from [1e-06:inf);

// file "Z:/SIdesign/NS1ellip3W//source/bsimcmg_body.include", line 264
parameter real K11 = 0.0;

// file "Z:/SIdesign/NS1ellip3W//source/bsimcmg_body.include", line 265
parameter real K2SAT = 0.0;

// file "Z:/SIdesign/NS1ellip3W//source/bsimcmg_body.include", line 266
parameter real K2SAT1 = 0.0;

// file "Z:/SIdesign/NS1ellip3W//source/bsimcmg_body.include", line 267
parameter real K2 = 0.0;

// file "Z:/SIdesign/NS1ellip3W//source/bsimcmg_body.include", line 268
parameter real K21 = 0.0;

// file "Z:/SIdesign/NS1ellip3W//source/bsimcmg_body.include", line 271
parameter real QMFACTOR = 0.0;

// file "Z:/SIdesign/NS1ellip3W//source/bsimcmg_body.include", line 272
parameter real QMTCENCV = 0.0;

// file "Z:/SIdesign/NS1ellip3W//source/bsimcmg_body.include", line 273
parameter real QMTCENCVA = 0.0;

// file "Z:/SIdesign/NS1ellip3W//source/bsimcmg_body.include", line 274
parameter real AQMTCEN = 0.0;

// file "Z:/SIdesign/NS1ellip3W//source/bsimcmg_body.include", line 275
parameter real BQMTCEN = 1.2e-08 exclude 0.0;

// file "Z:/SIdesign/NS1ellip3W//source/bsimcmg_body.include", line 276
parameter real ETAQM = 0.54;

// file "Z:/SIdesign/NS1ellip3W//source/bsimcmg_body.include", line 277
parameter real QM0 = 0.001;

// file "Z:/SIdesign/NS1ellip3W//source/bsimcmg_body.include", line 278
parameter real PQM = 0.66;

// file "Z:/SIdesign/NS1ellip3W//source/bsimcmg_body.include", line 279
parameter real QM0ACC = 0.001;

// file "Z:/SIdesign/NS1ellip3W//source/bsimcmg_body.include", line 280
parameter real PQMACC = 0.66;

// file "Z:/SIdesign/NS1ellip3W//source/bsimcmg_body.include", line 283
parameter real VSAT = 85000.0;

// file "Z:/SIdesign/NS1ellip3W//source/bsimcmg_body.include", line 284
parameter real VSATR = VSAT;

// file "Z:/SIdesign/NS1ellip3W//source/bsimcmg_body.include", line 285
parameter real VSATN1 = 0.0;

// file "Z:/SIdesign/NS1ellip3W//source/bsimcmg_body.include", line 286
parameter real VSATN2 = 100000.0 exclude 0.0;

// file "Z:/SIdesign/NS1ellip3W//source/bsimcmg_body.include", line 287
parameter real VSATRN1 = VSATN1;

// file "Z:/SIdesign/NS1ellip3W//source/bsimcmg_body.include", line 288
parameter real VSATRN2 = VSATN2 exclude 0.0;

// file "Z:/SIdesign/NS1ellip3W//source/bsimcmg_body.include", line 289
parameter real AVSAT = 0.0;

// file "Z:/SIdesign/NS1ellip3W//source/bsimcmg_body.include", line 290
parameter real BVSAT = 1e-07 exclude 0.0;

// file "Z:/SIdesign/NS1ellip3W//source/bsimcmg_body.include", line 291
parameter real VSAT1 = VSAT;

// file "Z:/SIdesign/NS1ellip3W//source/bsimcmg_body.include", line 292
parameter real VSAT1N1 = VSATN1;

// file "Z:/SIdesign/NS1ellip3W//source/bsimcmg_body.include", line 293
parameter real VSAT1N2 = VSATN2 exclude 0.0;

// file "Z:/SIdesign/NS1ellip3W//source/bsimcmg_body.include", line 294
parameter real VSAT1R = VSAT1;

// file "Z:/SIdesign/NS1ellip3W//source/bsimcmg_body.include", line 295
parameter real VSAT1RN1 = VSAT1N1;

// file "Z:/SIdesign/NS1ellip3W//source/bsimcmg_body.include", line 296
parameter real VSAT1RN2 = VSAT1N2 exclude 0.0;

// file "Z:/SIdesign/NS1ellip3W//source/bsimcmg_body.include", line 297
parameter real AVSAT1 = AVSAT;

// file "Z:/SIdesign/NS1ellip3W//source/bsimcmg_body.include", line 298
parameter real BVSAT1 = BVSAT exclude 0.0;

// file "Z:/SIdesign/NS1ellip3W//source/bsimcmg_body.include", line 299
parameter real DELTAVSAT = 1.0;

// file "Z:/SIdesign/NS1ellip3W//source/bsimcmg_body.include", line 300
parameter real PSAT = 2.0;

// file "Z:/SIdesign/NS1ellip3W//source/bsimcmg_body.include", line 301
parameter real APSAT = 0.0;

// file "Z:/SIdesign/NS1ellip3W//source/bsimcmg_body.include", line 302
parameter real BPSAT = 1.0 exclude 0.0;

// file "Z:/SIdesign/NS1ellip3W//source/bsimcmg_body.include", line 303
parameter real KSATIV = 1.0;

// file "Z:/SIdesign/NS1ellip3W//source/bsimcmg_body.include", line 304
parameter real KSATIVR = KSATIV;

// file "Z:/SIdesign/NS1ellip3W//source/bsimcmg_body.include", line 305
parameter real VSATCV = VSAT;

// file "Z:/SIdesign/NS1ellip3W//source/bsimcmg_body.include", line 306
parameter real AVSATCV = AVSAT;

// file "Z:/SIdesign/NS1ellip3W//source/bsimcmg_body.include", line 307
parameter real BVSATCV = BVSAT exclude 0.0;

// file "Z:/SIdesign/NS1ellip3W//source/bsimcmg_body.include", line 308
parameter real DELTAVSATCV = DELTAVSAT;

// file "Z:/SIdesign/NS1ellip3W//source/bsimcmg_body.include", line 309
parameter real PSATCV = PSAT;

// file "Z:/SIdesign/NS1ellip3W//source/bsimcmg_body.include", line 310
parameter real APSATCV = APSAT;

// file "Z:/SIdesign/NS1ellip3W//source/bsimcmg_body.include", line 311
parameter real BPSATCV = BPSAT exclude 0.0;

// file "Z:/SIdesign/NS1ellip3W//source/bsimcmg_body.include", line 312
parameter real MEXP = 4.0;

// file "Z:/SIdesign/NS1ellip3W//source/bsimcmg_body.include", line 313
parameter real AMEXP = 0.0;

// file "Z:/SIdesign/NS1ellip3W//source/bsimcmg_body.include", line 314
parameter real BMEXP = 1.0;

// file "Z:/SIdesign/NS1ellip3W//source/bsimcmg_body.include", line 315
parameter real MEXPR = MEXP;

// file "Z:/SIdesign/NS1ellip3W//source/bsimcmg_body.include", line 316
parameter real AMEXPR = AMEXP;

// file "Z:/SIdesign/NS1ellip3W//source/bsimcmg_body.include", line 317
parameter real BMEXPR = BMEXP;

// file "Z:/SIdesign/NS1ellip3W//source/bsimcmg_body.include", line 318
parameter real PTWG = 0.0;

// file "Z:/SIdesign/NS1ellip3W//source/bsimcmg_body.include", line 319
parameter real PTWGR = PTWG;

// file "Z:/SIdesign/NS1ellip3W//source/bsimcmg_body.include", line 320
parameter real APTWG = 0.0;

// file "Z:/SIdesign/NS1ellip3W//source/bsimcmg_body.include", line 321
parameter real BPTWG = 1e-07 exclude 0.0;

// file "Z:/SIdesign/NS1ellip3W//source/bsimcmg_body.include", line 322
parameter real AT = -0.00156;

// file "Z:/SIdesign/NS1ellip3W//source/bsimcmg_body.include", line 323
parameter real ATR = AT;

// file "Z:/SIdesign/NS1ellip3W//source/bsimcmg_body.include", line 324
parameter real ATCV = AT;

// file "Z:/SIdesign/NS1ellip3W//source/bsimcmg_body.include", line 325
parameter real TMEXP = 0.0;

// file "Z:/SIdesign/NS1ellip3W//source/bsimcmg_body.include", line 326
parameter real TMEXPR = TMEXP;

// file "Z:/SIdesign/NS1ellip3W//source/bsimcmg_body.include", line 327
parameter real PTWGT = 0.004;

// file "Z:/SIdesign/NS1ellip3W//source/bsimcmg_body.include", line 330
parameter real U0 = 0.03;

// file "Z:/SIdesign/NS1ellip3W//source/bsimcmg_body.include", line 331
parameter real U0R = U0;

// file "Z:/SIdesign/NS1ellip3W//source/bsimcmg_body.include", line 332
parameter real U0N1 = 0.0;

// file "Z:/SIdesign/NS1ellip3W//source/bsimcmg_body.include", line 333
parameter real U0N1R = U0N1;

// file "Z:/SIdesign/NS1ellip3W//source/bsimcmg_body.include", line 334
parameter real U0N2 = 100000.0 exclude 0.0;

// file "Z:/SIdesign/NS1ellip3W//source/bsimcmg_body.include", line 335
parameter real U0N2R = U0N2 exclude 0.0;

// file "Z:/SIdesign/NS1ellip3W//source/bsimcmg_body.include", line 336
parameter real U0LT = 0.0;

// file "Z:/SIdesign/NS1ellip3W//source/bsimcmg_body.include", line 337
parameter real ETAMOB = 2.0;

// file "Z:/SIdesign/NS1ellip3W//source/bsimcmg_body.include", line 338
parameter real UP = 0.0;

// file "Z:/SIdesign/NS1ellip3W//source/bsimcmg_body.include", line 339
parameter real LPA = 1.0;

// file "Z:/SIdesign/NS1ellip3W//source/bsimcmg_body.include", line 340
parameter real UPR = UP;

// file "Z:/SIdesign/NS1ellip3W//source/bsimcmg_body.include", line 341
parameter real LPAR = LPA;

// file "Z:/SIdesign/NS1ellip3W//source/bsimcmg_body.include", line 342
parameter real UA = 0.3;

// file "Z:/SIdesign/NS1ellip3W//source/bsimcmg_body.include", line 343
parameter real UAR = UA;

// file "Z:/SIdesign/NS1ellip3W//source/bsimcmg_body.include", line 344
parameter real AUA = 0.0;

// file "Z:/SIdesign/NS1ellip3W//source/bsimcmg_body.include", line 345
parameter real AUAR = AUA;

// file "Z:/SIdesign/NS1ellip3W//source/bsimcmg_body.include", line 346
parameter real BUA = 1e-07 exclude 0.0;

// file "Z:/SIdesign/NS1ellip3W//source/bsimcmg_body.include", line 347
parameter real BUAR = BUA exclude 0.0;

// file "Z:/SIdesign/NS1ellip3W//source/bsimcmg_body.include", line 348
parameter real UC = 0.0;

// file "Z:/SIdesign/NS1ellip3W//source/bsimcmg_body.include", line 349
parameter real UCR = UC;

// file "Z:/SIdesign/NS1ellip3W//source/bsimcmg_body.include", line 350
parameter real EU = 2.5;

// file "Z:/SIdesign/NS1ellip3W//source/bsimcmg_body.include", line 351
parameter real EUR = EU;

// file "Z:/SIdesign/NS1ellip3W//source/bsimcmg_body.include", line 352
parameter real AEU = 0.0;

// file "Z:/SIdesign/NS1ellip3W//source/bsimcmg_body.include", line 353
parameter real AEUR = AEU;

// file "Z:/SIdesign/NS1ellip3W//source/bsimcmg_body.include", line 354
parameter real BEU = 1e-07 exclude 0.0;

// file "Z:/SIdesign/NS1ellip3W//source/bsimcmg_body.include", line 355
parameter real BEUR = BEU exclude 0.0;

// file "Z:/SIdesign/NS1ellip3W//source/bsimcmg_body.include", line 356
parameter real UD = 0.0;

// file "Z:/SIdesign/NS1ellip3W//source/bsimcmg_body.include", line 357
parameter real UDR = UD;

// file "Z:/SIdesign/NS1ellip3W//source/bsimcmg_body.include", line 358
parameter real AUD = 0.0;

// file "Z:/SIdesign/NS1ellip3W//source/bsimcmg_body.include", line 359
parameter real AUDR = AUD;

// file "Z:/SIdesign/NS1ellip3W//source/bsimcmg_body.include", line 360
parameter real BUD = 5e-08 exclude 0.0;

// file "Z:/SIdesign/NS1ellip3W//source/bsimcmg_body.include", line 361
parameter real BUDR = BUD exclude 0.0;

// file "Z:/SIdesign/NS1ellip3W//source/bsimcmg_body.include", line 362
parameter real UCS = 1.0;

// file "Z:/SIdesign/NS1ellip3W//source/bsimcmg_body.include", line 363
parameter real UTE = 0.0;

// file "Z:/SIdesign/NS1ellip3W//source/bsimcmg_body.include", line 364
parameter real UTER = UTE;

// file "Z:/SIdesign/NS1ellip3W//source/bsimcmg_body.include", line 365
parameter real UTL = -0.0015;

// file "Z:/SIdesign/NS1ellip3W//source/bsimcmg_body.include", line 366
parameter real UTLR = UTL;

// file "Z:/SIdesign/NS1ellip3W//source/bsimcmg_body.include", line 367
parameter real EMOBT = 0.0;

// file "Z:/SIdesign/NS1ellip3W//source/bsimcmg_body.include", line 368
parameter real UA1 = 0.001032;

// file "Z:/SIdesign/NS1ellip3W//source/bsimcmg_body.include", line 369
parameter real UA1R = UA1;

// file "Z:/SIdesign/NS1ellip3W//source/bsimcmg_body.include", line 370
parameter real UC1 = 5.6e-11;

// file "Z:/SIdesign/NS1ellip3W//source/bsimcmg_body.include", line 371
parameter real UC1R = UC1;

// file "Z:/SIdesign/NS1ellip3W//source/bsimcmg_body.include", line 372
parameter real UD1 = 0.0;

// file "Z:/SIdesign/NS1ellip3W//source/bsimcmg_body.include", line 373
parameter real UD1R = UD1;

// file "Z:/SIdesign/NS1ellip3W//source/bsimcmg_body.include", line 374
parameter real UCSTE = -0.004775;

// file "Z:/SIdesign/NS1ellip3W//source/bsimcmg_body.include", line 375
parameter real CHARGEWF = 0.0 from [-1.0:1.0];

// file "Z:/SIdesign/NS1ellip3W//source/bsimcmg_body.include", line 378
parameter real RDSWMIN = 0.0;

// file "Z:/SIdesign/NS1ellip3W//source/bsimcmg_body.include", line 379
parameter real RDSW = 100.0;

// file "Z:/SIdesign/NS1ellip3W//source/bsimcmg_body.include", line 380
parameter real ARDSW = 0.0;

// file "Z:/SIdesign/NS1ellip3W//source/bsimcmg_body.include", line 381
parameter real BRDSW = 1e-07 exclude 0.0;

// file "Z:/SIdesign/NS1ellip3W//source/bsimcmg_body.include", line 382
parameter real RSWMIN = 0.0;

// file "Z:/SIdesign/NS1ellip3W//source/bsimcmg_body.include", line 383
parameter real RSW = 50.0;

// file "Z:/SIdesign/NS1ellip3W//source/bsimcmg_body.include", line 384
parameter real ARSW = 0.0;

// file "Z:/SIdesign/NS1ellip3W//source/bsimcmg_body.include", line 385
parameter real BRSW = 1e-07 exclude 0.0;

// file "Z:/SIdesign/NS1ellip3W//source/bsimcmg_body.include", line 386
parameter real RDWMIN = 0.0;

// file "Z:/SIdesign/NS1ellip3W//source/bsimcmg_body.include", line 387
parameter real RDW = 50.0;

// file "Z:/SIdesign/NS1ellip3W//source/bsimcmg_body.include", line 388
parameter real ARDW = 0.0;

// file "Z:/SIdesign/NS1ellip3W//source/bsimcmg_body.include", line 389
parameter real BRDW = 1e-07 exclude 0.0;

// file "Z:/SIdesign/NS1ellip3W//source/bsimcmg_body.include", line 390
parameter real RSDR = 0.0 from [0:inf);

// file "Z:/SIdesign/NS1ellip3W//source/bsimcmg_body.include", line 391
parameter real RSDRR = RSDR from [0:inf);

// file "Z:/SIdesign/NS1ellip3W//source/bsimcmg_body.include", line 392
parameter real RDDR = RSDR from [0:inf);

// file "Z:/SIdesign/NS1ellip3W//source/bsimcmg_body.include", line 393
parameter real RDDRR = RDDR from [0:inf);

// file "Z:/SIdesign/NS1ellip3W//source/bsimcmg_body.include", line 394
parameter real PRSDR = 1.0;

// file "Z:/SIdesign/NS1ellip3W//source/bsimcmg_body.include", line 395
parameter real PRDDR = PRSDR;

// file "Z:/SIdesign/NS1ellip3W//source/bsimcmg_body.include", line 396
parameter real PRWGS = 0.0;

// file "Z:/SIdesign/NS1ellip3W//source/bsimcmg_body.include", line 397
parameter real PRWGD = PRWGS;

// file "Z:/SIdesign/NS1ellip3W//source/bsimcmg_body.include", line 398
parameter real WR = 1.0;

// file "Z:/SIdesign/NS1ellip3W//source/bsimcmg_body.include", line 399
parameter real PRT = 0.001;

// file "Z:/SIdesign/NS1ellip3W//source/bsimcmg_body.include", line 400
parameter real TRSDR = 0.0;

// file "Z:/SIdesign/NS1ellip3W//source/bsimcmg_body.include", line 401
parameter real TRDDR = TRSDR;

// file "Z:/SIdesign/NS1ellip3W//source/bsimcmg_body.include", line 404
parameter real PDIBL1 = 1.3;

// file "Z:/SIdesign/NS1ellip3W//source/bsimcmg_body.include", line 405
parameter real PDIBL1R = PDIBL1;

// file "Z:/SIdesign/NS1ellip3W//source/bsimcmg_body.include", line 406
parameter real PDIBL2 = 0.0002;

// file "Z:/SIdesign/NS1ellip3W//source/bsimcmg_body.include", line 407
parameter real PDIBL2R = PDIBL2;

// file "Z:/SIdesign/NS1ellip3W//source/bsimcmg_body.include", line 408
parameter real DROUT = 1.06;

// file "Z:/SIdesign/NS1ellip3W//source/bsimcmg_body.include", line 409
parameter real PVAG = 1.0;

// file "Z:/SIdesign/NS1ellip3W//source/bsimcmg_body.include", line 412
parameter real PCLM = 0.013;

// file "Z:/SIdesign/NS1ellip3W//source/bsimcmg_body.include", line 413
parameter real PCLMR = PCLM;

// file "Z:/SIdesign/NS1ellip3W//source/bsimcmg_body.include", line 414
parameter real APCLM = 0.0;

// file "Z:/SIdesign/NS1ellip3W//source/bsimcmg_body.include", line 415
parameter real APCLMR = APCLM;

// file "Z:/SIdesign/NS1ellip3W//source/bsimcmg_body.include", line 416
parameter real BPCLM = 1e-07 exclude 0.0;

// file "Z:/SIdesign/NS1ellip3W//source/bsimcmg_body.include", line 417
parameter real BPCLMR = BPCLM exclude 0.0;

// file "Z:/SIdesign/NS1ellip3W//source/bsimcmg_body.include", line 418
parameter real PCLMG = 0.0;

// file "Z:/SIdesign/NS1ellip3W//source/bsimcmg_body.include", line 419
parameter real PCLMCV = PCLM;

// file "Z:/SIdesign/NS1ellip3W//source/bsimcmg_body.include", line 422
parameter real A1 = 0.0;

// file "Z:/SIdesign/NS1ellip3W//source/bsimcmg_body.include", line 423
parameter real A11 = 0.0;

// file "Z:/SIdesign/NS1ellip3W//source/bsimcmg_body.include", line 424
parameter real A2 = 0.0;

// file "Z:/SIdesign/NS1ellip3W//source/bsimcmg_body.include", line 425
parameter real A21 = 0.0;

// file "Z:/SIdesign/NS1ellip3W//source/bsimcmg_body.include", line 428
parameter real RGEXT = 0.0 from [0:inf);

// file "Z:/SIdesign/NS1ellip3W//source/bsimcmg_body.include", line 429
parameter real RGFIN = 0.001 from [0.001:inf);

// file "Z:/SIdesign/NS1ellip3W//source/bsimcmg_body.include", line 432
parameter real RSHS = 0.0;

// file "Z:/SIdesign/NS1ellip3W//source/bsimcmg_body.include", line 433
parameter real RSHD = RSHS;

// file "Z:/SIdesign/NS1ellip3W//source/bsimcmg_body.include", line 437
parameter real HEPI = 1e-08;

// file "Z:/SIdesign/NS1ellip3W//source/bsimcmg_body.include", line 438
parameter real TSILI = 1e-08;

// file "Z:/SIdesign/NS1ellip3W//source/bsimcmg_body.include", line 439
parameter real RHOC = 1e-12 from [1.0000000000000001e-18:1e-09];

// file "Z:/SIdesign/NS1ellip3W//source/bsimcmg_body.include", line 440
parameter real RHORSD = 1.0 from (0:inf);

// file "Z:/SIdesign/NS1ellip3W//source/bsimcmg_body.include", line 441
parameter real CRATIO = 0.5 from [0.0:1.0];

// file "Z:/SIdesign/NS1ellip3W//source/bsimcmg_body.include", line 442
parameter real DELTAPRSD = 0.0 from (-FPITCH:inf);

// file "Z:/SIdesign/NS1ellip3W//source/bsimcmg_body.include", line 443
parameter integer SDTERM = 0 from [0:1];

// file "Z:/SIdesign/NS1ellip3W//source/bsimcmg_body.include", line 444
parameter real LSP = (0.2 * (L + XL));

// file "Z:/SIdesign/NS1ellip3W//source/bsimcmg_body.include", line 445
parameter real EPSRSP = 3.9 from [1.0:inf);

// file "Z:/SIdesign/NS1ellip3W//source/bsimcmg_body.include", line 446
parameter real TGATE = 3e-08 from (0:inf);

// file "Z:/SIdesign/NS1ellip3W//source/bsimcmg_body.include", line 447
parameter real TMASK = 3e-08 from [0:inf);

// file "Z:/SIdesign/NS1ellip3W//source/bsimcmg_body.include", line 448
parameter real ASILIEND = 0.0 from [0:inf);

// file "Z:/SIdesign/NS1ellip3W//source/bsimcmg_body.include", line 449
parameter real ARSDEND = 0.0 from [0:inf);

// file "Z:/SIdesign/NS1ellip3W//source/bsimcmg_body.include", line 450
parameter real PRSDEND = 0.0 from [0:inf);

// file "Z:/SIdesign/NS1ellip3W//source/bsimcmg_body.include", line 451
parameter real NSDE = 2.000000000000e+25 from [1.000000000000e+25:1.000000000000e+26];

// file "Z:/SIdesign/NS1ellip3W//source/bsimcmg_body.include", line 452
parameter real RGEOA = 1.0;

// file "Z:/SIdesign/NS1ellip3W//source/bsimcmg_body.include", line 453
parameter real RGEOB = 0.0;

// file "Z:/SIdesign/NS1ellip3W//source/bsimcmg_body.include", line 454
parameter real RGEOC = 0.0;

// file "Z:/SIdesign/NS1ellip3W//source/bsimcmg_body.include", line 455
parameter real RGEOD = 0.0;

// file "Z:/SIdesign/NS1ellip3W//source/bsimcmg_body.include", line 456
parameter real RGEOE = 0.0;

// file "Z:/SIdesign/NS1ellip3W//source/bsimcmg_body.include", line 457
parameter real CGEOA = 1.0;

// file "Z:/SIdesign/NS1ellip3W//source/bsimcmg_body.include", line 458
parameter real CGEOB = 0.0;

// file "Z:/SIdesign/NS1ellip3W//source/bsimcmg_body.include", line 459
parameter real CGEOC = 0.0;

// file "Z:/SIdesign/NS1ellip3W//source/bsimcmg_body.include", line 460
parameter real CGEOD = 0.0;

// file "Z:/SIdesign/NS1ellip3W//source/bsimcmg_body.include", line 461
parameter real CGEOE = 1.0 from [0:inf);

// file "Z:/SIdesign/NS1ellip3W//source/bsimcmg_body.include", line 464
parameter real AIGBINV = 0.0111;

// file "Z:/SIdesign/NS1ellip3W//source/bsimcmg_body.include", line 465
parameter real AIGBINV1 = 0.0;

// file "Z:/SIdesign/NS1ellip3W//source/bsimcmg_body.include", line 466
parameter real BIGBINV = 0.000949;

// file "Z:/SIdesign/NS1ellip3W//source/bsimcmg_body.include", line 467
parameter real CIGBINV = 0.006;

// file "Z:/SIdesign/NS1ellip3W//source/bsimcmg_body.include", line 468
parameter real EIGBINV = 1.1;

// file "Z:/SIdesign/NS1ellip3W//source/bsimcmg_body.include", line 469
parameter real NIGBINV = 3.0;

// file "Z:/SIdesign/NS1ellip3W//source/bsimcmg_body.include", line 470
parameter real AIGBACC = 0.0136;

// file "Z:/SIdesign/NS1ellip3W//source/bsimcmg_body.include", line 471
parameter real AIGBACC1 = 0.0;

// file "Z:/SIdesign/NS1ellip3W//source/bsimcmg_body.include", line 472
parameter real BIGBACC = 0.00171;

// file "Z:/SIdesign/NS1ellip3W//source/bsimcmg_body.include", line 473
parameter real CIGBACC = 0.075;

// file "Z:/SIdesign/NS1ellip3W//source/bsimcmg_body.include", line 474
parameter real NIGBACC = 1.0;

// file "Z:/SIdesign/NS1ellip3W//source/bsimcmg_body.include", line 475
parameter real AIGC = 0.0136;

// file "Z:/SIdesign/NS1ellip3W//source/bsimcmg_body.include", line 476
parameter real AIGC1 = 0.0;

// file "Z:/SIdesign/NS1ellip3W//source/bsimcmg_body.include", line 477
parameter real BIGC = 0.00171;

// file "Z:/SIdesign/NS1ellip3W//source/bsimcmg_body.include", line 478
parameter real CIGC = 0.075;

// file "Z:/SIdesign/NS1ellip3W//source/bsimcmg_body.include", line 479
parameter real PIGCD = 1.0;

// file "Z:/SIdesign/NS1ellip3W//source/bsimcmg_body.include", line 480
parameter real DLCIGS = 0.0;

// file "Z:/SIdesign/NS1ellip3W//source/bsimcmg_body.include", line 481
parameter real AIGS = 0.0136;

// file "Z:/SIdesign/NS1ellip3W//source/bsimcmg_body.include", line 482
parameter real AIGS1 = 0.0;

// file "Z:/SIdesign/NS1ellip3W//source/bsimcmg_body.include", line 483
parameter real BIGS = 0.00171;

// file "Z:/SIdesign/NS1ellip3W//source/bsimcmg_body.include", line 484
parameter real CIGS = 0.075;

// file "Z:/SIdesign/NS1ellip3W//source/bsimcmg_body.include", line 485
parameter real DLCIGD = DLCIGS;

// file "Z:/SIdesign/NS1ellip3W//source/bsimcmg_body.include", line 486
parameter real AIGD = AIGS;

// file "Z:/SIdesign/NS1ellip3W//source/bsimcmg_body.include", line 487
parameter real AIGD1 = AIGS1;

// file "Z:/SIdesign/NS1ellip3W//source/bsimcmg_body.include", line 488
parameter real BIGD = BIGS;

// file "Z:/SIdesign/NS1ellip3W//source/bsimcmg_body.include", line 489
parameter real CIGD = CIGS;

// file "Z:/SIdesign/NS1ellip3W//source/bsimcmg_body.include", line 490
parameter real VFBSD = 0.0;

// file "Z:/SIdesign/NS1ellip3W//source/bsimcmg_body.include", line 491
parameter real VFBSDCV = VFBSD;

// file "Z:/SIdesign/NS1ellip3W//source/bsimcmg_body.include", line 492
parameter real TOXREF = 1.2e-09 from (0:inf);

// file "Z:/SIdesign/NS1ellip3W//source/bsimcmg_body.include", line 493
parameter real TOXG = TOXP;

// file "Z:/SIdesign/NS1ellip3W//source/bsimcmg_body.include", line 494
parameter real NTOX = 1.0;

// file "Z:/SIdesign/NS1ellip3W//source/bsimcmg_body.include", line 495
parameter real POXEDGE = 1.0;

// file "Z:/SIdesign/NS1ellip3W//source/bsimcmg_body.include", line 498
parameter real AGISL = 6.055e-12;

// file "Z:/SIdesign/NS1ellip3W//source/bsimcmg_body.include", line 499
parameter real BGISL = 3.000000000000e+08;

// file "Z:/SIdesign/NS1ellip3W//source/bsimcmg_body.include", line 500
parameter real CGISL = 0.5;

// file "Z:/SIdesign/NS1ellip3W//source/bsimcmg_body.include", line 501
parameter real EGISL = 0.2;

// file "Z:/SIdesign/NS1ellip3W//source/bsimcmg_body.include", line 502
parameter real PGISL = 1.0;

// file "Z:/SIdesign/NS1ellip3W//source/bsimcmg_body.include", line 503
parameter real AGIDL = AGISL;

// file "Z:/SIdesign/NS1ellip3W//source/bsimcmg_body.include", line 504
parameter real BGIDL = BGISL;

// file "Z:/SIdesign/NS1ellip3W//source/bsimcmg_body.include", line 505
parameter real CGIDL = CGISL;

// file "Z:/SIdesign/NS1ellip3W//source/bsimcmg_body.include", line 506
parameter real EGIDL = EGISL;

// file "Z:/SIdesign/NS1ellip3W//source/bsimcmg_body.include", line 507
parameter real PGIDL = PGISL;

// file "Z:/SIdesign/NS1ellip3W//source/bsimcmg_body.include", line 511
parameter real ALPHA0 = 0.0;

// file "Z:/SIdesign/NS1ellip3W//source/bsimcmg_body.include", line 512
parameter real ALPHA01 = 0.0;

// file "Z:/SIdesign/NS1ellip3W//source/bsimcmg_body.include", line 513
parameter real ALPHA1 = 0.0;

// file "Z:/SIdesign/NS1ellip3W//source/bsimcmg_body.include", line 514
parameter real ALPHA11 = 0.0;

// file "Z:/SIdesign/NS1ellip3W//source/bsimcmg_body.include", line 515
parameter real BETA0 = 0.0;

// file "Z:/SIdesign/NS1ellip3W//source/bsimcmg_body.include", line 518
parameter real ALPHAII0 = 0.0;

// file "Z:/SIdesign/NS1ellip3W//source/bsimcmg_body.include", line 519
parameter real ALPHAII01 = 0.0;

// file "Z:/SIdesign/NS1ellip3W//source/bsimcmg_body.include", line 520
parameter real ALPHAII1 = 0.0;

// file "Z:/SIdesign/NS1ellip3W//source/bsimcmg_body.include", line 521
parameter real ALPHAII11 = 0.0;

// file "Z:/SIdesign/NS1ellip3W//source/bsimcmg_body.include", line 522
parameter real BETAII0 = 0.0;

// file "Z:/SIdesign/NS1ellip3W//source/bsimcmg_body.include", line 523
parameter real BETAII1 = 0.0;

// file "Z:/SIdesign/NS1ellip3W//source/bsimcmg_body.include", line 524
parameter real BETAII2 = 0.1;

// file "Z:/SIdesign/NS1ellip3W//source/bsimcmg_body.include", line 525
parameter real ESATII = 10000000.0;

// file "Z:/SIdesign/NS1ellip3W//source/bsimcmg_body.include", line 526
parameter real LII = 5e-10;

// file "Z:/SIdesign/NS1ellip3W//source/bsimcmg_body.include", line 527
parameter real SII0 = 0.5;

// file "Z:/SIdesign/NS1ellip3W//source/bsimcmg_body.include", line 528
parameter real SII1 = 0.1;

// file "Z:/SIdesign/NS1ellip3W//source/bsimcmg_body.include", line 529
parameter real SII2 = 0.0;

// file "Z:/SIdesign/NS1ellip3W//source/bsimcmg_body.include", line 530
parameter real SIID = 0.0;

// file "Z:/SIdesign/NS1ellip3W//source/bsimcmg_body.include", line 531
parameter real IIMOD2CLAMP1 = 0.1 from (0.0:inf);

// file "Z:/SIdesign/NS1ellip3W//source/bsimcmg_body.include", line 532
parameter real IIMOD2CLAMP2 = 0.1 from (0.0:inf);

// file "Z:/SIdesign/NS1ellip3W//source/bsimcmg_body.include", line 533
parameter real IIMOD2CLAMP3 = 0.1 from (0.0:inf);

// file "Z:/SIdesign/NS1ellip3W//source/bsimcmg_body.include", line 536
parameter real EOTACC = EOT from [1e-10:inf);

// file "Z:/SIdesign/NS1ellip3W//source/bsimcmg_body.include", line 537
parameter real DELVFBACC = 0.0;

// file "Z:/SIdesign/NS1ellip3W//source/bsimcmg_body.include", line 541
parameter real CFS = 2.5e-11 from [0:inf);

// file "Z:/SIdesign/NS1ellip3W//source/bsimcmg_body.include", line 542
parameter real CFD = CFS from [0:inf);

// file "Z:/SIdesign/NS1ellip3W//source/bsimcmg_body.include", line 545
parameter real CGSO = 0.0 from [0:inf);

// file "Z:/SIdesign/NS1ellip3W//source/bsimcmg_body.include", line 546
parameter real CGDO = CGSO from [0:inf);

// file "Z:/SIdesign/NS1ellip3W//source/bsimcmg_body.include", line 547
parameter real CGSL = 0.0 from [0:inf);

// file "Z:/SIdesign/NS1ellip3W//source/bsimcmg_body.include", line 548
parameter real CGDL = CGSL from [0:inf);

// file "Z:/SIdesign/NS1ellip3W//source/bsimcmg_body.include", line 549
parameter real CKAPPAS = 0.6 from [0.02:inf);

// file "Z:/SIdesign/NS1ellip3W//source/bsimcmg_body.include", line 550
parameter real CKAPPAD = CKAPPAS from [0.02:inf);

// file "Z:/SIdesign/NS1ellip3W//source/bsimcmg_body.include", line 551
parameter real CGBO = 0.0 from [0:inf);

// file "Z:/SIdesign/NS1ellip3W//source/bsimcmg_body.include", line 552
parameter real CGBN = 0.0 from [0:inf);

// file "Z:/SIdesign/NS1ellip3W//source/bsimcmg_body.include", line 553
parameter real CGBL = 0.0 from [0:inf);

// file "Z:/SIdesign/NS1ellip3W//source/bsimcmg_body.include", line 554
parameter real CKAPPAB = 0.6 from [0.02:inf);

// file "Z:/SIdesign/NS1ellip3W//source/bsimcmg_body.include", line 557
parameter real CSDESW = 0.0 from [0:inf);

// file "Z:/SIdesign/NS1ellip3W//source/bsimcmg_body.include", line 561
parameter real CJS = 0.0005;

// file "Z:/SIdesign/NS1ellip3W//source/bsimcmg_body.include", line 562
parameter real CJD = CJS;

// file "Z:/SIdesign/NS1ellip3W//source/bsimcmg_body.include", line 563
parameter real CJSWS = 5e-10;

// file "Z:/SIdesign/NS1ellip3W//source/bsimcmg_body.include", line 564
parameter real CJSWD = CJSWS;

// file "Z:/SIdesign/NS1ellip3W//source/bsimcmg_body.include", line 565
parameter real CJSWGS = 0.0;

// file "Z:/SIdesign/NS1ellip3W//source/bsimcmg_body.include", line 566
parameter real CJSWGD = CJSWGS;

// file "Z:/SIdesign/NS1ellip3W//source/bsimcmg_body.include", line 567
parameter real PBS = 1.0;

// file "Z:/SIdesign/NS1ellip3W//source/bsimcmg_body.include", line 568
parameter real PBD = PBS;

// file "Z:/SIdesign/NS1ellip3W//source/bsimcmg_body.include", line 569
parameter real PBSWS = 1.0;

// file "Z:/SIdesign/NS1ellip3W//source/bsimcmg_body.include", line 570
parameter real PBSWD = PBSWS;

// file "Z:/SIdesign/NS1ellip3W//source/bsimcmg_body.include", line 571
parameter real PBSWGS = PBSWS;

// file "Z:/SIdesign/NS1ellip3W//source/bsimcmg_body.include", line 572
parameter real PBSWGD = PBSWGS;

// file "Z:/SIdesign/NS1ellip3W//source/bsimcmg_body.include", line 573
parameter real MJS = 0.5;

// file "Z:/SIdesign/NS1ellip3W//source/bsimcmg_body.include", line 574
parameter real MJD = MJS;

// file "Z:/SIdesign/NS1ellip3W//source/bsimcmg_body.include", line 575
parameter real MJSWS = 0.33;

// file "Z:/SIdesign/NS1ellip3W//source/bsimcmg_body.include", line 576
parameter real MJSWD = MJSWS;

// file "Z:/SIdesign/NS1ellip3W//source/bsimcmg_body.include", line 577
parameter real MJSWGS = MJSWS;

// file "Z:/SIdesign/NS1ellip3W//source/bsimcmg_body.include", line 578
parameter real MJSWGD = MJSWGS;

// file "Z:/SIdesign/NS1ellip3W//source/bsimcmg_body.include", line 581
parameter real SJS = 0.0 from [0:inf);

// file "Z:/SIdesign/NS1ellip3W//source/bsimcmg_body.include", line 582
parameter real SJD = SJS from [0:inf);

// file "Z:/SIdesign/NS1ellip3W//source/bsimcmg_body.include", line 583
parameter real SJSWS = 0.0 from [0:inf);

// file "Z:/SIdesign/NS1ellip3W//source/bsimcmg_body.include", line 584
parameter real SJSWD = SJSWS from [0:inf);

// file "Z:/SIdesign/NS1ellip3W//source/bsimcmg_body.include", line 585
parameter real SJSWGS = 0.0 from [0:inf);

// file "Z:/SIdesign/NS1ellip3W//source/bsimcmg_body.include", line 586
parameter real SJSWGD = SJSWGS from [0:inf);

// file "Z:/SIdesign/NS1ellip3W//source/bsimcmg_body.include", line 587
parameter real MJS2 = 0.125;

// file "Z:/SIdesign/NS1ellip3W//source/bsimcmg_body.include", line 588
parameter real MJD2 = MJS2;

// file "Z:/SIdesign/NS1ellip3W//source/bsimcmg_body.include", line 589
parameter real MJSWS2 = 0.083;

// file "Z:/SIdesign/NS1ellip3W//source/bsimcmg_body.include", line 590
parameter real MJSWD2 = MJSWS2;

// file "Z:/SIdesign/NS1ellip3W//source/bsimcmg_body.include", line 591
parameter real MJSWGS2 = MJSWS2;

// file "Z:/SIdesign/NS1ellip3W//source/bsimcmg_body.include", line 592
parameter real MJSWGD2 = MJSWGS2;

// file "Z:/SIdesign/NS1ellip3W//source/bsimcmg_body.include", line 595
parameter real JSS = 0.0001;

// file "Z:/SIdesign/NS1ellip3W//source/bsimcmg_body.include", line 596
parameter real JSD = JSS;

// file "Z:/SIdesign/NS1ellip3W//source/bsimcmg_body.include", line 597
parameter real JSWS = 0.0;

// file "Z:/SIdesign/NS1ellip3W//source/bsimcmg_body.include", line 598
parameter real JSWD = JSWS;

// file "Z:/SIdesign/NS1ellip3W//source/bsimcmg_body.include", line 599
parameter real JSWGS = 0.0;

// file "Z:/SIdesign/NS1ellip3W//source/bsimcmg_body.include", line 600
parameter real JSWGD = JSWGS;

// file "Z:/SIdesign/NS1ellip3W//source/bsimcmg_body.include", line 601
parameter real NJS = 1.0 exclude 0.0;

// file "Z:/SIdesign/NS1ellip3W//source/bsimcmg_body.include", line 602
parameter real NJD = NJS exclude 0.0;

// file "Z:/SIdesign/NS1ellip3W//source/bsimcmg_body.include", line 603
parameter real IJTHSFWD = 0.1;

// file "Z:/SIdesign/NS1ellip3W//source/bsimcmg_body.include", line 604
parameter real IJTHDFWD = IJTHSFWD;

// file "Z:/SIdesign/NS1ellip3W//source/bsimcmg_body.include", line 605
parameter real IJTHSREV = 0.1;

// file "Z:/SIdesign/NS1ellip3W//source/bsimcmg_body.include", line 606
parameter real IJTHDREV = IJTHSREV;

// file "Z:/SIdesign/NS1ellip3W//source/bsimcmg_body.include", line 607
parameter real BVS = 10.0;

// file "Z:/SIdesign/NS1ellip3W//source/bsimcmg_body.include", line 608
parameter real BVD = BVS;

// file "Z:/SIdesign/NS1ellip3W//source/bsimcmg_body.include", line 609
parameter real XJBVS = 1.0;

// file "Z:/SIdesign/NS1ellip3W//source/bsimcmg_body.include", line 610
parameter real XJBVD = XJBVS;

// file "Z:/SIdesign/NS1ellip3W//source/bsimcmg_body.include", line 613
parameter real JTSS = 0.0;

// file "Z:/SIdesign/NS1ellip3W//source/bsimcmg_body.include", line 614
parameter real JTSD = JTSS;

// file "Z:/SIdesign/NS1ellip3W//source/bsimcmg_body.include", line 615
parameter real JTSSWS = 0.0;

// file "Z:/SIdesign/NS1ellip3W//source/bsimcmg_body.include", line 616
parameter real JTSSWD = JTSSWS;

// file "Z:/SIdesign/NS1ellip3W//source/bsimcmg_body.include", line 617
parameter real JTSSWGS = 0.0;

// file "Z:/SIdesign/NS1ellip3W//source/bsimcmg_body.include", line 618
parameter real JTSSWGD = JTSSWGS;

// file "Z:/SIdesign/NS1ellip3W//source/bsimcmg_body.include", line 619
parameter real JTWEFF = 0.0;

// file "Z:/SIdesign/NS1ellip3W//source/bsimcmg_body.include", line 620
parameter real NJTS = 20.0;

// file "Z:/SIdesign/NS1ellip3W//source/bsimcmg_body.include", line 621
parameter real NJTSD = NJTS;

// file "Z:/SIdesign/NS1ellip3W//source/bsimcmg_body.include", line 622
parameter real NJTSSW = 20.0;

// file "Z:/SIdesign/NS1ellip3W//source/bsimcmg_body.include", line 623
parameter real NJTSSWD = NJTSSW;

// file "Z:/SIdesign/NS1ellip3W//source/bsimcmg_body.include", line 624
parameter real NJTSSWG = 20.0;

// file "Z:/SIdesign/NS1ellip3W//source/bsimcmg_body.include", line 625
parameter real NJTSSWGD = NJTSSWG;

// file "Z:/SIdesign/NS1ellip3W//source/bsimcmg_body.include", line 626
parameter real VTSS = 10.0;

// file "Z:/SIdesign/NS1ellip3W//source/bsimcmg_body.include", line 627
parameter real VTSD = VTSS;

// file "Z:/SIdesign/NS1ellip3W//source/bsimcmg_body.include", line 628
parameter real VTSSWS = 10.0;

// file "Z:/SIdesign/NS1ellip3W//source/bsimcmg_body.include", line 629
parameter real VTSSWD = VTSSWS;

// file "Z:/SIdesign/NS1ellip3W//source/bsimcmg_body.include", line 630
parameter real VTSSWGS = 10.0;

// file "Z:/SIdesign/NS1ellip3W//source/bsimcmg_body.include", line 631
parameter real VTSSWGD = VTSSWGS;

// file "Z:/SIdesign/NS1ellip3W//source/bsimcmg_body.include", line 634
parameter real LINTIGEN = 0.0;

// file "Z:/SIdesign/NS1ellip3W//source/bsimcmg_body.include", line 635
parameter real NTGEN = 1.0;

// file "Z:/SIdesign/NS1ellip3W//source/bsimcmg_body.include", line 636
parameter real AIGEN = 0.0;

// file "Z:/SIdesign/NS1ellip3W//source/bsimcmg_body.include", line 637
parameter real BIGEN = 0.0;

// file "Z:/SIdesign/NS1ellip3W//source/bsimcmg_body.include", line 641
parameter real XRCRG1 = 12.0;

// file "Z:/SIdesign/NS1ellip3W//source/bsimcmg_body.include", line 642
parameter real XRCRG2 = 1.0;

// file "Z:/SIdesign/NS1ellip3W//source/bsimcmg_body.include", line 645
parameter integer NSEG = 4 from [4:10];

// file "Z:/SIdesign/NS1ellip3W//source/bsimcmg_body.include", line 648
parameter real EF = 1.0;

// file "Z:/SIdesign/NS1ellip3W//source/bsimcmg_body.include", line 649
parameter real EM = 41000000.0;

// file "Z:/SIdesign/NS1ellip3W//source/bsimcmg_body.include", line 650
parameter real NOIA = 6.250000000000e+39;

// file "Z:/SIdesign/NS1ellip3W//source/bsimcmg_body.include", line 651
parameter real NOIB = 3.125000000000e+24;

// file "Z:/SIdesign/NS1ellip3W//source/bsimcmg_body.include", line 652
parameter real NOIC = 87500000.0;

// file "Z:/SIdesign/NS1ellip3W//source/bsimcmg_body.include", line 653
parameter real LINTNOI = 0.0;

// file "Z:/SIdesign/NS1ellip3W//source/bsimcmg_body.include", line 656
parameter real NTNOI = 1.0 from [0:inf);

// file "Z:/SIdesign/NS1ellip3W//source/bsimcmg_body.include", line 657
parameter real TNOIA = 1.5;

// file "Z:/SIdesign/NS1ellip3W//source/bsimcmg_body.include", line 658
parameter real TNOIB = 3.5;

// file "Z:/SIdesign/NS1ellip3W//source/bsimcmg_body.include", line 659
parameter real RNOIA = 0.577;

// file "Z:/SIdesign/NS1ellip3W//source/bsimcmg_body.include", line 660
parameter real RNOIB = 0.37;

// file "Z:/SIdesign/NS1ellip3W//source/bsimcmg_body.include", line 664
parameter real TNOIC = 3.5;

// file "Z:/SIdesign/NS1ellip3W//source/bsimcmg_body.include", line 665
parameter real RNOIC = 0.395;

// file "Z:/SIdesign/NS1ellip3W//source/bsimcmg_body.include", line 666
parameter real SCALEN = 100000.0 exclude 0.0;

// file "Z:/SIdesign/NS1ellip3W//source/bsimcmg_body.include", line 670
parameter real TNOM = 27.0 from [-273.15:inf);

// file "Z:/SIdesign/NS1ellip3W//source/bsimcmg_body.include", line 671
parameter real TBGASUB = 0.000702;

// file "Z:/SIdesign/NS1ellip3W//source/bsimcmg_body.include", line 672
parameter real TBGBSUB = 1108.0;

// file "Z:/SIdesign/NS1ellip3W//source/bsimcmg_body.include", line 673
parameter real KT1 = 0.0;

// file "Z:/SIdesign/NS1ellip3W//source/bsimcmg_body.include", line 674
parameter real KT1L = 0.0;

// file "Z:/SIdesign/NS1ellip3W//source/bsimcmg_body.include", line 675
parameter real TSS = 0.0;

// file "Z:/SIdesign/NS1ellip3W//source/bsimcmg_body.include", line 676
parameter real IIT = -0.5;

// file "Z:/SIdesign/NS1ellip3W//source/bsimcmg_body.include", line 677
parameter real TII = 0.0;

// file "Z:/SIdesign/NS1ellip3W//source/bsimcmg_body.include", line 678
parameter real TGIDL = -0.003;

// file "Z:/SIdesign/NS1ellip3W//source/bsimcmg_body.include", line 679
parameter real IGT = 2.5;

// file "Z:/SIdesign/NS1ellip3W//source/bsimcmg_body.include", line 680
parameter real TCJ = 0.0;

// file "Z:/SIdesign/NS1ellip3W//source/bsimcmg_body.include", line 681
parameter real TCJSW = 0.0;

// file "Z:/SIdesign/NS1ellip3W//source/bsimcmg_body.include", line 682
parameter real TCJSWG = 0.0;

// file "Z:/SIdesign/NS1ellip3W//source/bsimcmg_body.include", line 683
parameter real TPB = 0.0;

// file "Z:/SIdesign/NS1ellip3W//source/bsimcmg_body.include", line 684
parameter real TPBSW = 0.0;

// file "Z:/SIdesign/NS1ellip3W//source/bsimcmg_body.include", line 685
parameter real TPBSWG = 0.0;

// file "Z:/SIdesign/NS1ellip3W//source/bsimcmg_body.include", line 686
parameter real XTIS = 3.0;

// file "Z:/SIdesign/NS1ellip3W//source/bsimcmg_body.include", line 687
parameter real XTID = XTIS;

// file "Z:/SIdesign/NS1ellip3W//source/bsimcmg_body.include", line 688
parameter real XTSS = 0.02;

// file "Z:/SIdesign/NS1ellip3W//source/bsimcmg_body.include", line 689
parameter real XTSD = XTSS;

// file "Z:/SIdesign/NS1ellip3W//source/bsimcmg_body.include", line 690
parameter real XTSSWS = 0.02;

// file "Z:/SIdesign/NS1ellip3W//source/bsimcmg_body.include", line 691
parameter real XTSSWD = XTSSWS;

// file "Z:/SIdesign/NS1ellip3W//source/bsimcmg_body.include", line 692
parameter real XTSSWGS = 0.02;

// file "Z:/SIdesign/NS1ellip3W//source/bsimcmg_body.include", line 693
parameter real XTSSWGD = XTSSWGS;

// file "Z:/SIdesign/NS1ellip3W//source/bsimcmg_body.include", line 694
parameter real TNJTS = 0.0;

// file "Z:/SIdesign/NS1ellip3W//source/bsimcmg_body.include", line 695
parameter real TNJTSD = TNJTS;

// file "Z:/SIdesign/NS1ellip3W//source/bsimcmg_body.include", line 696
parameter real TNJTSSW = 0.0;

// file "Z:/SIdesign/NS1ellip3W//source/bsimcmg_body.include", line 697
parameter real TNJTSSWD = TNJTSSW;

// file "Z:/SIdesign/NS1ellip3W//source/bsimcmg_body.include", line 698
parameter real TNJTSSWG = 0.0;

// file "Z:/SIdesign/NS1ellip3W//source/bsimcmg_body.include", line 699
parameter real TNJTSSWGD = TNJTSSWG;

// file "Z:/SIdesign/NS1ellip3W//source/bsimcmg_body.include", line 702
parameter real RTH0 = 0.01 from [0:inf);

// file "Z:/SIdesign/NS1ellip3W//source/bsimcmg_body.include", line 703
parameter real CTH0 = 1e-05 from [0:inf);

// file "Z:/SIdesign/NS1ellip3W//source/bsimcmg_body.include", line 704
parameter real WTH0 = 0.0 from [0:inf);

// file "Z:/SIdesign/NS1ellip3W//source/bsimcmg_body.include", line 705
parameter real ASHEXP = 1.0 from [0:inf);

// file "Z:/SIdesign/NS1ellip3W//source/bsimcmg_body.include", line 706
parameter real BSHEXP = 1.0 from [0:inf);

// file "Z:/SIdesign/NS1ellip3W//source/bsimcmg_body.include", line 709
parameter real ACH_UFCM = 1.0 from (0:inf);

// file "Z:/SIdesign/NS1ellip3W//source/bsimcmg_body.include", line 710
parameter real CINS_UFCM = 1.0 from (0:inf);

// file "Z:/SIdesign/NS1ellip3W//source/bsimcmg_body.include", line 711
parameter real W_UFCM = 1.0 from (0:inf);

// file "Z:/SIdesign/NS1ellip3W//source/bsimcmg_body.include", line 712
parameter real TFIN_TOP = 1.5e-08 from [0:inf);

// file "Z:/SIdesign/NS1ellip3W//source/bsimcmg_body.include", line 713
parameter real TFIN_BASE = 1.5e-08 from [1e-09:inf);

// file "Z:/SIdesign/NS1ellip3W//source/bsimcmg_body.include", line 714
parameter real QMFACTORCV = 0.0 from [0:inf);

// file "Z:/SIdesign/NS1ellip3W//source/bsimcmg_body.include", line 715
parameter real ALPHA_UFCM = 0.5556 from [0:inf);

// file "Z:/SIdesign/NS1ellip3W//source/bsimcmg_body.include", line 42
parameter real LNBODY = 0.0;

// file "Z:/SIdesign/NS1ellip3W//source/bsimcmg_body.include", line 43
parameter real NNBODY = 0.0;

// file "Z:/SIdesign/NS1ellip3W//source/bsimcmg_body.include", line 44
parameter real PNBODY = 0.0;

// file "Z:/SIdesign/NS1ellip3W//source/bsimcmg_body.include", line 46
parameter real LPHIG = 0.0;

// file "Z:/SIdesign/NS1ellip3W//source/bsimcmg_body.include", line 47
parameter real NPHIG = 0.0;

// file "Z:/SIdesign/NS1ellip3W//source/bsimcmg_body.include", line 48
parameter real PPHIG = 0.0;

// file "Z:/SIdesign/NS1ellip3W//source/bsimcmg_body.include", line 50
parameter real LNGATE = 0.0;

// file "Z:/SIdesign/NS1ellip3W//source/bsimcmg_body.include", line 51
parameter real NNGATE = 0.0;

// file "Z:/SIdesign/NS1ellip3W//source/bsimcmg_body.include", line 52
parameter real PNGATE = 0.0;

// file "Z:/SIdesign/NS1ellip3W//source/bsimcmg_body.include", line 54
parameter real LCIT = 0.0;

// file "Z:/SIdesign/NS1ellip3W//source/bsimcmg_body.include", line 55
parameter real NCIT = 0.0;

// file "Z:/SIdesign/NS1ellip3W//source/bsimcmg_body.include", line 56
parameter real PCIT = 0.0;

// file "Z:/SIdesign/NS1ellip3W//source/bsimcmg_body.include", line 58
parameter real LCITR = LCIT;

// file "Z:/SIdesign/NS1ellip3W//source/bsimcmg_body.include", line 59
parameter real NCITR = NCIT;

// file "Z:/SIdesign/NS1ellip3W//source/bsimcmg_body.include", line 60
parameter real PCITR = PCIT;

// file "Z:/SIdesign/NS1ellip3W//source/bsimcmg_body.include", line 62
parameter real LCDSC = 0.0;

// file "Z:/SIdesign/NS1ellip3W//source/bsimcmg_body.include", line 63
parameter real NCDSC = 0.0;

// file "Z:/SIdesign/NS1ellip3W//source/bsimcmg_body.include", line 64
parameter real PCDSC = 0.0;

// file "Z:/SIdesign/NS1ellip3W//source/bsimcmg_body.include", line 66
parameter real LCDSCD = 0.0;

// file "Z:/SIdesign/NS1ellip3W//source/bsimcmg_body.include", line 67
parameter real NCDSCD = 0.0;

// file "Z:/SIdesign/NS1ellip3W//source/bsimcmg_body.include", line 68
parameter real PCDSCD = 0.0;

// file "Z:/SIdesign/NS1ellip3W//source/bsimcmg_body.include", line 70
parameter real LCDSCDR = LCDSCD;

// file "Z:/SIdesign/NS1ellip3W//source/bsimcmg_body.include", line 71
parameter real NCDSCDR = NCDSCD;

// file "Z:/SIdesign/NS1ellip3W//source/bsimcmg_body.include", line 72
parameter real PCDSCDR = PCDSCD;

// file "Z:/SIdesign/NS1ellip3W//source/bsimcmg_body.include", line 74
parameter real LDVT0 = 0.0;

// file "Z:/SIdesign/NS1ellip3W//source/bsimcmg_body.include", line 75
parameter real NDVT0 = 0.0;

// file "Z:/SIdesign/NS1ellip3W//source/bsimcmg_body.include", line 76
parameter real PDVT0 = 0.0;

// file "Z:/SIdesign/NS1ellip3W//source/bsimcmg_body.include", line 78
parameter real LDVT1 = 0.0;

// file "Z:/SIdesign/NS1ellip3W//source/bsimcmg_body.include", line 79
parameter real NDVT1 = 0.0;

// file "Z:/SIdesign/NS1ellip3W//source/bsimcmg_body.include", line 80
parameter real PDVT1 = 0.0;

// file "Z:/SIdesign/NS1ellip3W//source/bsimcmg_body.include", line 82
parameter real LDVT1SS = LDVT1;

// file "Z:/SIdesign/NS1ellip3W//source/bsimcmg_body.include", line 83
parameter real NDVT1SS = NDVT1;

// file "Z:/SIdesign/NS1ellip3W//source/bsimcmg_body.include", line 84
parameter real PDVT1SS = PDVT1;

// file "Z:/SIdesign/NS1ellip3W//source/bsimcmg_body.include", line 86
parameter real LPHIN = 0.0;

// file "Z:/SIdesign/NS1ellip3W//source/bsimcmg_body.include", line 87
parameter real NPHIN = 0.0;

// file "Z:/SIdesign/NS1ellip3W//source/bsimcmg_body.include", line 88
parameter real PPHIN = 0.0;

// file "Z:/SIdesign/NS1ellip3W//source/bsimcmg_body.include", line 90
parameter real LETA0 = 0.0;

// file "Z:/SIdesign/NS1ellip3W//source/bsimcmg_body.include", line 91
parameter real NETA0 = 0.0;

// file "Z:/SIdesign/NS1ellip3W//source/bsimcmg_body.include", line 92
parameter real PETA0 = 0.0;

// file "Z:/SIdesign/NS1ellip3W//source/bsimcmg_body.include", line 94
parameter real LETA0R = LETA0;

// file "Z:/SIdesign/NS1ellip3W//source/bsimcmg_body.include", line 95
parameter real NETA0R = NETA0;

// file "Z:/SIdesign/NS1ellip3W//source/bsimcmg_body.include", line 96
parameter real PETA0R = PETA0;

// file "Z:/SIdesign/NS1ellip3W//source/bsimcmg_body.include", line 98
parameter real LDSUB = 0.0;

// file "Z:/SIdesign/NS1ellip3W//source/bsimcmg_body.include", line 99
parameter real NDSUB = 0.0;

// file "Z:/SIdesign/NS1ellip3W//source/bsimcmg_body.include", line 100
parameter real PDSUB = 0.0;

// file "Z:/SIdesign/NS1ellip3W//source/bsimcmg_body.include", line 102
parameter real LK1RSCE = 0.0;

// file "Z:/SIdesign/NS1ellip3W//source/bsimcmg_body.include", line 103
parameter real NK1RSCE = 0.0;

// file "Z:/SIdesign/NS1ellip3W//source/bsimcmg_body.include", line 104
parameter real PK1RSCE = 0.0;

// file "Z:/SIdesign/NS1ellip3W//source/bsimcmg_body.include", line 106
parameter real LLPE0 = 0.0;

// file "Z:/SIdesign/NS1ellip3W//source/bsimcmg_body.include", line 107
parameter real NLPE0 = 0.0;

// file "Z:/SIdesign/NS1ellip3W//source/bsimcmg_body.include", line 108
parameter real PLPE0 = 0.0;

// file "Z:/SIdesign/NS1ellip3W//source/bsimcmg_body.include", line 110
parameter real LDVTSHIFT = 0.0;

// file "Z:/SIdesign/NS1ellip3W//source/bsimcmg_body.include", line 111
parameter real NDVTSHIFT = 0.0;

// file "Z:/SIdesign/NS1ellip3W//source/bsimcmg_body.include", line 112
parameter real PDVTSHIFT = 0.0;

// file "Z:/SIdesign/NS1ellip3W//source/bsimcmg_body.include", line 114
parameter real LDVTSHIFTR = LDVTSHIFT;

// file "Z:/SIdesign/NS1ellip3W//source/bsimcmg_body.include", line 115
parameter real NDVTSHIFTR = NDVTSHIFT;

// file "Z:/SIdesign/NS1ellip3W//source/bsimcmg_body.include", line 116
parameter real PDVTSHIFTR = PDVTSHIFT;

// file "Z:/SIdesign/NS1ellip3W//source/bsimcmg_body.include", line 118
parameter real LPHIBE = 0.0;

// file "Z:/SIdesign/NS1ellip3W//source/bsimcmg_body.include", line 119
parameter real NPHIBE = 0.0;

// file "Z:/SIdesign/NS1ellip3W//source/bsimcmg_body.include", line 120
parameter real PPHIBE = 0.0;

// file "Z:/SIdesign/NS1ellip3W//source/bsimcmg_body.include", line 122
parameter real LK0 = 0.0;

// file "Z:/SIdesign/NS1ellip3W//source/bsimcmg_body.include", line 123
parameter real NK0 = 0.0;

// file "Z:/SIdesign/NS1ellip3W//source/bsimcmg_body.include", line 124
parameter real PK0 = 0.0;

// file "Z:/SIdesign/NS1ellip3W//source/bsimcmg_body.include", line 126
parameter real LK01 = 0.0;

// file "Z:/SIdesign/NS1ellip3W//source/bsimcmg_body.include", line 127
parameter real NK01 = 0.0;

// file "Z:/SIdesign/NS1ellip3W//source/bsimcmg_body.include", line 128
parameter real PK01 = 0.0;

// file "Z:/SIdesign/NS1ellip3W//source/bsimcmg_body.include", line 130
parameter real LK0SI = 0.0;

// file "Z:/SIdesign/NS1ellip3W//source/bsimcmg_body.include", line 131
parameter real NK0SI = 0.0;

// file "Z:/SIdesign/NS1ellip3W//source/bsimcmg_body.include", line 132
parameter real PK0SI = 0.0;

// file "Z:/SIdesign/NS1ellip3W//source/bsimcmg_body.include", line 134
parameter real LK0SI1 = 0.0;

// file "Z:/SIdesign/NS1ellip3W//source/bsimcmg_body.include", line 135
parameter real NK0SI1 = 0.0;

// file "Z:/SIdesign/NS1ellip3W//source/bsimcmg_body.include", line 136
parameter real PK0SI1 = 0.0;

// file "Z:/SIdesign/NS1ellip3W//source/bsimcmg_body.include", line 138
parameter real LK1 = 0.0;

// file "Z:/SIdesign/NS1ellip3W//source/bsimcmg_body.include", line 139
parameter real NK1 = 0.0;

// file "Z:/SIdesign/NS1ellip3W//source/bsimcmg_body.include", line 140
parameter real PK1 = 0.0;

// file "Z:/SIdesign/NS1ellip3W//source/bsimcmg_body.include", line 142
parameter real LK11 = 0.0;

// file "Z:/SIdesign/NS1ellip3W//source/bsimcmg_body.include", line 143
parameter real NK11 = 0.0;

// file "Z:/SIdesign/NS1ellip3W//source/bsimcmg_body.include", line 144
parameter real PK11 = 0.0;

// file "Z:/SIdesign/NS1ellip3W//source/bsimcmg_body.include", line 146
parameter real LK2SI = LK0SI;

// file "Z:/SIdesign/NS1ellip3W//source/bsimcmg_body.include", line 147
parameter real NK2SI = NK0SI;

// file "Z:/SIdesign/NS1ellip3W//source/bsimcmg_body.include", line 148
parameter real PK2SI = PK0SI;

// file "Z:/SIdesign/NS1ellip3W//source/bsimcmg_body.include", line 150
parameter real LK2SI1 = LK0SI1;

// file "Z:/SIdesign/NS1ellip3W//source/bsimcmg_body.include", line 151
parameter real NK2SI1 = NK0SI1;

// file "Z:/SIdesign/NS1ellip3W//source/bsimcmg_body.include", line 152
parameter real PK2SI1 = PK0SI1;

// file "Z:/SIdesign/NS1ellip3W//source/bsimcmg_body.include", line 154
parameter real LK0SISAT = 0.0;

// file "Z:/SIdesign/NS1ellip3W//source/bsimcmg_body.include", line 155
parameter real NK0SISAT = 0.0;

// file "Z:/SIdesign/NS1ellip3W//source/bsimcmg_body.include", line 156
parameter real PK0SISAT = 0.0;

// file "Z:/SIdesign/NS1ellip3W//source/bsimcmg_body.include", line 158
parameter real LK0SISAT1 = 0.0;

// file "Z:/SIdesign/NS1ellip3W//source/bsimcmg_body.include", line 159
parameter real NK0SISAT1 = 0.0;

// file "Z:/SIdesign/NS1ellip3W//source/bsimcmg_body.include", line 160
parameter real PK0SISAT1 = 0.0;

// file "Z:/SIdesign/NS1ellip3W//source/bsimcmg_body.include", line 162
parameter real LK2SISAT = LK0SISAT;

// file "Z:/SIdesign/NS1ellip3W//source/bsimcmg_body.include", line 163
parameter real NK2SISAT = NK0SISAT;

// file "Z:/SIdesign/NS1ellip3W//source/bsimcmg_body.include", line 164
parameter real PK2SISAT = PK0SISAT;

// file "Z:/SIdesign/NS1ellip3W//source/bsimcmg_body.include", line 166
parameter real LK2SISAT1 = LK0SISAT1;

// file "Z:/SIdesign/NS1ellip3W//source/bsimcmg_body.include", line 167
parameter real NK2SISAT1 = NK0SISAT1;

// file "Z:/SIdesign/NS1ellip3W//source/bsimcmg_body.include", line 168
parameter real PK2SISAT1 = PK0SISAT1;

// file "Z:/SIdesign/NS1ellip3W//source/bsimcmg_body.include", line 170
parameter real LK2SAT = 0.0;

// file "Z:/SIdesign/NS1ellip3W//source/bsimcmg_body.include", line 171
parameter real NK2SAT = 0.0;

// file "Z:/SIdesign/NS1ellip3W//source/bsimcmg_body.include", line 172
parameter real PK2SAT = 0.0;

// file "Z:/SIdesign/NS1ellip3W//source/bsimcmg_body.include", line 174
parameter real LK2SAT1 = 0.0;

// file "Z:/SIdesign/NS1ellip3W//source/bsimcmg_body.include", line 175
parameter real NK2SAT1 = 0.0;

// file "Z:/SIdesign/NS1ellip3W//source/bsimcmg_body.include", line 176
parameter real PK2SAT1 = 0.0;

// file "Z:/SIdesign/NS1ellip3W//source/bsimcmg_body.include", line 178
parameter real LK2 = 0.0;

// file "Z:/SIdesign/NS1ellip3W//source/bsimcmg_body.include", line 179
parameter real NK2 = 0.0;

// file "Z:/SIdesign/NS1ellip3W//source/bsimcmg_body.include", line 180
parameter real PK2 = 0.0;

// file "Z:/SIdesign/NS1ellip3W//source/bsimcmg_body.include", line 182
parameter real LK21 = 0.0;

// file "Z:/SIdesign/NS1ellip3W//source/bsimcmg_body.include", line 183
parameter real NK21 = 0.0;

// file "Z:/SIdesign/NS1ellip3W//source/bsimcmg_body.include", line 184
parameter real PK21 = 0.0;

// file "Z:/SIdesign/NS1ellip3W//source/bsimcmg_body.include", line 186
parameter real LDVTB = 0.0;

// file "Z:/SIdesign/NS1ellip3W//source/bsimcmg_body.include", line 187
parameter real NDVTB = 0.0;

// file "Z:/SIdesign/NS1ellip3W//source/bsimcmg_body.include", line 188
parameter real PDVTB = 0.0;

// file "Z:/SIdesign/NS1ellip3W//source/bsimcmg_body.include", line 190
parameter real LLPEB = 0.0;

// file "Z:/SIdesign/NS1ellip3W//source/bsimcmg_body.include", line 191
parameter real NLPEB = 0.0;

// file "Z:/SIdesign/NS1ellip3W//source/bsimcmg_body.include", line 192
parameter real PLPEB = 0.0;

// file "Z:/SIdesign/NS1ellip3W//source/bsimcmg_body.include", line 194
parameter real LQMFACTOR = 0.0;

// file "Z:/SIdesign/NS1ellip3W//source/bsimcmg_body.include", line 195
parameter real NQMFACTOR = 0.0;

// file "Z:/SIdesign/NS1ellip3W//source/bsimcmg_body.include", line 196
parameter real PQMFACTOR = 0.0;

// file "Z:/SIdesign/NS1ellip3W//source/bsimcmg_body.include", line 198
parameter real LQMTCENCV = 0.0;

// file "Z:/SIdesign/NS1ellip3W//source/bsimcmg_body.include", line 199
parameter real NQMTCENCV = 0.0;

// file "Z:/SIdesign/NS1ellip3W//source/bsimcmg_body.include", line 200
parameter real PQMTCENCV = 0.0;

// file "Z:/SIdesign/NS1ellip3W//source/bsimcmg_body.include", line 202
parameter real LQMTCENCVA = 0.0;

// file "Z:/SIdesign/NS1ellip3W//source/bsimcmg_body.include", line 203
parameter real NQMTCENCVA = 0.0;

// file "Z:/SIdesign/NS1ellip3W//source/bsimcmg_body.include", line 204
parameter real PQMTCENCVA = 0.0;

// file "Z:/SIdesign/NS1ellip3W//source/bsimcmg_body.include", line 206
parameter real LVSAT = 0.0;

// file "Z:/SIdesign/NS1ellip3W//source/bsimcmg_body.include", line 207
parameter real NVSAT = 0.0;

// file "Z:/SIdesign/NS1ellip3W//source/bsimcmg_body.include", line 208
parameter real PVSAT = 0.0;

// file "Z:/SIdesign/NS1ellip3W//source/bsimcmg_body.include", line 210
parameter real LVSATR = LVSAT;

// file "Z:/SIdesign/NS1ellip3W//source/bsimcmg_body.include", line 211
parameter real NVSATR = NVSAT;

// file "Z:/SIdesign/NS1ellip3W//source/bsimcmg_body.include", line 212
parameter real PVSATR = PVSAT;

// file "Z:/SIdesign/NS1ellip3W//source/bsimcmg_body.include", line 214
parameter real LVSAT1 = LVSAT;

// file "Z:/SIdesign/NS1ellip3W//source/bsimcmg_body.include", line 215
parameter real NVSAT1 = NVSAT;

// file "Z:/SIdesign/NS1ellip3W//source/bsimcmg_body.include", line 216
parameter real PVSAT1 = PVSAT;

// file "Z:/SIdesign/NS1ellip3W//source/bsimcmg_body.include", line 218
parameter real LVSAT1R = LVSAT1;

// file "Z:/SIdesign/NS1ellip3W//source/bsimcmg_body.include", line 219
parameter real NVSAT1R = NVSAT1;

// file "Z:/SIdesign/NS1ellip3W//source/bsimcmg_body.include", line 220
parameter real PVSAT1R = PVSAT1;

// file "Z:/SIdesign/NS1ellip3W//source/bsimcmg_body.include", line 222
parameter real LPSAT = 0.0;

// file "Z:/SIdesign/NS1ellip3W//source/bsimcmg_body.include", line 223
parameter real NPSAT = 0.0;

// file "Z:/SIdesign/NS1ellip3W//source/bsimcmg_body.include", line 224
parameter real PPSAT = 0.0;

// file "Z:/SIdesign/NS1ellip3W//source/bsimcmg_body.include", line 226
parameter real LDELTAVSAT = 0.0;

// file "Z:/SIdesign/NS1ellip3W//source/bsimcmg_body.include", line 227
parameter real NDELTAVSAT = 0.0;

// file "Z:/SIdesign/NS1ellip3W//source/bsimcmg_body.include", line 228
parameter real PDELTAVSAT = 0.0;

// file "Z:/SIdesign/NS1ellip3W//source/bsimcmg_body.include", line 230
parameter real LKSATIV = 0.0;

// file "Z:/SIdesign/NS1ellip3W//source/bsimcmg_body.include", line 231
parameter real NKSATIV = 0.0;

// file "Z:/SIdesign/NS1ellip3W//source/bsimcmg_body.include", line 232
parameter real PKSATIV = 0.0;

// file "Z:/SIdesign/NS1ellip3W//source/bsimcmg_body.include", line 234
parameter real LKSATIVR = LKSATIV;

// file "Z:/SIdesign/NS1ellip3W//source/bsimcmg_body.include", line 235
parameter real NKSATIVR = NKSATIV;

// file "Z:/SIdesign/NS1ellip3W//source/bsimcmg_body.include", line 236
parameter real PKSATIVR = PKSATIV;

// file "Z:/SIdesign/NS1ellip3W//source/bsimcmg_body.include", line 238
parameter real LVSATCV = 0.0;

// file "Z:/SIdesign/NS1ellip3W//source/bsimcmg_body.include", line 239
parameter real NVSATCV = 0.0;

// file "Z:/SIdesign/NS1ellip3W//source/bsimcmg_body.include", line 240
parameter real PVSATCV = 0.0;

// file "Z:/SIdesign/NS1ellip3W//source/bsimcmg_body.include", line 242
parameter real LPSATCV = 0.0;

// file "Z:/SIdesign/NS1ellip3W//source/bsimcmg_body.include", line 243
parameter real NPSATCV = 0.0;

// file "Z:/SIdesign/NS1ellip3W//source/bsimcmg_body.include", line 244
parameter real PPSATCV = 0.0;

// file "Z:/SIdesign/NS1ellip3W//source/bsimcmg_body.include", line 246
parameter real LDELTAVSATCV = 0.0;

// file "Z:/SIdesign/NS1ellip3W//source/bsimcmg_body.include", line 247
parameter real NDELTAVSATCV = 0.0;

// file "Z:/SIdesign/NS1ellip3W//source/bsimcmg_body.include", line 248
parameter real PDELTAVSATCV = 0.0;

// file "Z:/SIdesign/NS1ellip3W//source/bsimcmg_body.include", line 250
parameter real LMEXP = 0.0;

// file "Z:/SIdesign/NS1ellip3W//source/bsimcmg_body.include", line 251
parameter real NMEXP = 0.0;

// file "Z:/SIdesign/NS1ellip3W//source/bsimcmg_body.include", line 252
parameter real PMEXP = 0.0;

// file "Z:/SIdesign/NS1ellip3W//source/bsimcmg_body.include", line 254
parameter real LMEXPR = LMEXP;

// file "Z:/SIdesign/NS1ellip3W//source/bsimcmg_body.include", line 255
parameter real NMEXPR = NMEXP;

// file "Z:/SIdesign/NS1ellip3W//source/bsimcmg_body.include", line 256
parameter real PMEXPR = PMEXP;

// file "Z:/SIdesign/NS1ellip3W//source/bsimcmg_body.include", line 258
parameter real LPTWG = 0.0;

// file "Z:/SIdesign/NS1ellip3W//source/bsimcmg_body.include", line 259
parameter real NPTWG = 0.0;

// file "Z:/SIdesign/NS1ellip3W//source/bsimcmg_body.include", line 260
parameter real PPTWG = 0.0;

// file "Z:/SIdesign/NS1ellip3W//source/bsimcmg_body.include", line 262
parameter real LPTWGR = LPTWG;

// file "Z:/SIdesign/NS1ellip3W//source/bsimcmg_body.include", line 263
parameter real NPTWGR = NPTWG;

// file "Z:/SIdesign/NS1ellip3W//source/bsimcmg_body.include", line 264
parameter real PPTWGR = PPTWG;

// file "Z:/SIdesign/NS1ellip3W//source/bsimcmg_body.include", line 266
parameter real LU0 = 0.0;

// file "Z:/SIdesign/NS1ellip3W//source/bsimcmg_body.include", line 267
parameter real NU0 = 0.0;

// file "Z:/SIdesign/NS1ellip3W//source/bsimcmg_body.include", line 268
parameter real PU0 = 0.0;

// file "Z:/SIdesign/NS1ellip3W//source/bsimcmg_body.include", line 270
parameter real LU0R = LU0;

// file "Z:/SIdesign/NS1ellip3W//source/bsimcmg_body.include", line 271
parameter real NU0R = NU0;

// file "Z:/SIdesign/NS1ellip3W//source/bsimcmg_body.include", line 272
parameter real PU0R = PU0;

// file "Z:/SIdesign/NS1ellip3W//source/bsimcmg_body.include", line 274
parameter real LETAMOB = 0.0;

// file "Z:/SIdesign/NS1ellip3W//source/bsimcmg_body.include", line 275
parameter real NETAMOB = 0.0;

// file "Z:/SIdesign/NS1ellip3W//source/bsimcmg_body.include", line 276
parameter real PETAMOB = 0.0;

// file "Z:/SIdesign/NS1ellip3W//source/bsimcmg_body.include", line 278
parameter real LUP = 0.0;

// file "Z:/SIdesign/NS1ellip3W//source/bsimcmg_body.include", line 279
parameter real NUP = 0.0;

// file "Z:/SIdesign/NS1ellip3W//source/bsimcmg_body.include", line 280
parameter real PUP = 0.0;

// file "Z:/SIdesign/NS1ellip3W//source/bsimcmg_body.include", line 282
parameter real LUPR = LUP;

// file "Z:/SIdesign/NS1ellip3W//source/bsimcmg_body.include", line 283
parameter real NUPR = NUP;

// file "Z:/SIdesign/NS1ellip3W//source/bsimcmg_body.include", line 284
parameter real PUPR = PUP;

// file "Z:/SIdesign/NS1ellip3W//source/bsimcmg_body.include", line 286
parameter real LUA = 0.0;

// file "Z:/SIdesign/NS1ellip3W//source/bsimcmg_body.include", line 287
parameter real NUA = 0.0;

// file "Z:/SIdesign/NS1ellip3W//source/bsimcmg_body.include", line 288
parameter real PUA = 0.0;

// file "Z:/SIdesign/NS1ellip3W//source/bsimcmg_body.include", line 290
parameter real LUAR = LUA;

// file "Z:/SIdesign/NS1ellip3W//source/bsimcmg_body.include", line 291
parameter real NUAR = NUA;

// file "Z:/SIdesign/NS1ellip3W//source/bsimcmg_body.include", line 292
parameter real PUAR = PUA;

// file "Z:/SIdesign/NS1ellip3W//source/bsimcmg_body.include", line 294
parameter real LUC = 0.0;

// file "Z:/SIdesign/NS1ellip3W//source/bsimcmg_body.include", line 295
parameter real NUC = 0.0;

// file "Z:/SIdesign/NS1ellip3W//source/bsimcmg_body.include", line 296
parameter real PUC = 0.0;

// file "Z:/SIdesign/NS1ellip3W//source/bsimcmg_body.include", line 298
parameter real LUCR = LUC;

// file "Z:/SIdesign/NS1ellip3W//source/bsimcmg_body.include", line 299
parameter real NUCR = NUC;

// file "Z:/SIdesign/NS1ellip3W//source/bsimcmg_body.include", line 300
parameter real PUCR = PUC;

// file "Z:/SIdesign/NS1ellip3W//source/bsimcmg_body.include", line 302
parameter real LEU = 0.0;

// file "Z:/SIdesign/NS1ellip3W//source/bsimcmg_body.include", line 303
parameter real NEU = 0.0;

// file "Z:/SIdesign/NS1ellip3W//source/bsimcmg_body.include", line 304
parameter real PEU = 0.0;

// file "Z:/SIdesign/NS1ellip3W//source/bsimcmg_body.include", line 306
parameter real LEUR = LEU;

// file "Z:/SIdesign/NS1ellip3W//source/bsimcmg_body.include", line 307
parameter real NEUR = NEU;

// file "Z:/SIdesign/NS1ellip3W//source/bsimcmg_body.include", line 308
parameter real PEUR = PEU;

// file "Z:/SIdesign/NS1ellip3W//source/bsimcmg_body.include", line 310
parameter real LUD = 0.0;

// file "Z:/SIdesign/NS1ellip3W//source/bsimcmg_body.include", line 311
parameter real NUD = 0.0;

// file "Z:/SIdesign/NS1ellip3W//source/bsimcmg_body.include", line 312
parameter real PUD = 0.0;

// file "Z:/SIdesign/NS1ellip3W//source/bsimcmg_body.include", line 314
parameter real LUDR = LUD;

// file "Z:/SIdesign/NS1ellip3W//source/bsimcmg_body.include", line 315
parameter real NUDR = NUD;

// file "Z:/SIdesign/NS1ellip3W//source/bsimcmg_body.include", line 316
parameter real PUDR = PUD;

// file "Z:/SIdesign/NS1ellip3W//source/bsimcmg_body.include", line 318
parameter real LUCS = 0.0;

// file "Z:/SIdesign/NS1ellip3W//source/bsimcmg_body.include", line 319
parameter real NUCS = 0.0;

// file "Z:/SIdesign/NS1ellip3W//source/bsimcmg_body.include", line 320
parameter real PUCS = 0.0;

// file "Z:/SIdesign/NS1ellip3W//source/bsimcmg_body.include", line 322
parameter real LPCLM = 0.0;

// file "Z:/SIdesign/NS1ellip3W//source/bsimcmg_body.include", line 323
parameter real NPCLM = 0.0;

// file "Z:/SIdesign/NS1ellip3W//source/bsimcmg_body.include", line 324
parameter real PPCLM = 0.0;

// file "Z:/SIdesign/NS1ellip3W//source/bsimcmg_body.include", line 326
parameter real LPCLMR = LPCLM;

// file "Z:/SIdesign/NS1ellip3W//source/bsimcmg_body.include", line 327
parameter real NPCLMR = NPCLM;

// file "Z:/SIdesign/NS1ellip3W//source/bsimcmg_body.include", line 328
parameter real PPCLMR = PPCLM;

// file "Z:/SIdesign/NS1ellip3W//source/bsimcmg_body.include", line 330
parameter real LPCLMG = 0.0;

// file "Z:/SIdesign/NS1ellip3W//source/bsimcmg_body.include", line 331
parameter real NPCLMG = 0.0;

// file "Z:/SIdesign/NS1ellip3W//source/bsimcmg_body.include", line 332
parameter real PPCLMG = 0.0;

// file "Z:/SIdesign/NS1ellip3W//source/bsimcmg_body.include", line 334
parameter real LPCLMCV = LPCLM;

// file "Z:/SIdesign/NS1ellip3W//source/bsimcmg_body.include", line 335
parameter real NPCLMCV = NPCLM;

// file "Z:/SIdesign/NS1ellip3W//source/bsimcmg_body.include", line 336
parameter real PPCLMCV = PPCLM;

// file "Z:/SIdesign/NS1ellip3W//source/bsimcmg_body.include", line 338
parameter real LA1 = 0.0;

// file "Z:/SIdesign/NS1ellip3W//source/bsimcmg_body.include", line 339
parameter real NA1 = 0.0;

// file "Z:/SIdesign/NS1ellip3W//source/bsimcmg_body.include", line 340
parameter real PA1 = 0.0;

// file "Z:/SIdesign/NS1ellip3W//source/bsimcmg_body.include", line 342
parameter real LA11 = 0.0;

// file "Z:/SIdesign/NS1ellip3W//source/bsimcmg_body.include", line 343
parameter real NA11 = 0.0;

// file "Z:/SIdesign/NS1ellip3W//source/bsimcmg_body.include", line 344
parameter real PA11 = 0.0;

// file "Z:/SIdesign/NS1ellip3W//source/bsimcmg_body.include", line 346
parameter real LA2 = 0.0;

// file "Z:/SIdesign/NS1ellip3W//source/bsimcmg_body.include", line 347
parameter real NA2 = 0.0;

// file "Z:/SIdesign/NS1ellip3W//source/bsimcmg_body.include", line 348
parameter real PA2 = 0.0;

// file "Z:/SIdesign/NS1ellip3W//source/bsimcmg_body.include", line 350
parameter real LA21 = 0.0;

// file "Z:/SIdesign/NS1ellip3W//source/bsimcmg_body.include", line 351
parameter real NA21 = 0.0;

// file "Z:/SIdesign/NS1ellip3W//source/bsimcmg_body.include", line 352
parameter real PA21 = 0.0;

// file "Z:/SIdesign/NS1ellip3W//source/bsimcmg_body.include", line 354
parameter real LRDSW = 0.0;

// file "Z:/SIdesign/NS1ellip3W//source/bsimcmg_body.include", line 355
parameter real NRDSW = 0.0;

// file "Z:/SIdesign/NS1ellip3W//source/bsimcmg_body.include", line 356
parameter real PRDSW = 0.0;

// file "Z:/SIdesign/NS1ellip3W//source/bsimcmg_body.include", line 358
parameter real LRSW = 0.0;

// file "Z:/SIdesign/NS1ellip3W//source/bsimcmg_body.include", line 359
parameter real NRSW = 0.0;

// file "Z:/SIdesign/NS1ellip3W//source/bsimcmg_body.include", line 360
parameter real PRSW = 0.0;

// file "Z:/SIdesign/NS1ellip3W//source/bsimcmg_body.include", line 362
parameter real LRDW = 0.0;

// file "Z:/SIdesign/NS1ellip3W//source/bsimcmg_body.include", line 363
parameter real NRDW = 0.0;

// file "Z:/SIdesign/NS1ellip3W//source/bsimcmg_body.include", line 364
parameter real PRDW = 0.0;

// file "Z:/SIdesign/NS1ellip3W//source/bsimcmg_body.include", line 366
parameter real LPRWGS = 0.0;

// file "Z:/SIdesign/NS1ellip3W//source/bsimcmg_body.include", line 367
parameter real NPRWGS = 0.0;

// file "Z:/SIdesign/NS1ellip3W//source/bsimcmg_body.include", line 368
parameter real PPRWGS = 0.0;

// file "Z:/SIdesign/NS1ellip3W//source/bsimcmg_body.include", line 370
parameter real LPRWGD = 0.0;

// file "Z:/SIdesign/NS1ellip3W//source/bsimcmg_body.include", line 371
parameter real NPRWGD = 0.0;

// file "Z:/SIdesign/NS1ellip3W//source/bsimcmg_body.include", line 372
parameter real PPRWGD = 0.0;

// file "Z:/SIdesign/NS1ellip3W//source/bsimcmg_body.include", line 374
parameter real LWR = 0.0;

// file "Z:/SIdesign/NS1ellip3W//source/bsimcmg_body.include", line 375
parameter real NWR = 0.0;

// file "Z:/SIdesign/NS1ellip3W//source/bsimcmg_body.include", line 376
parameter real PWR = 0.0;

// file "Z:/SIdesign/NS1ellip3W//source/bsimcmg_body.include", line 378
parameter real LPDIBL1 = 0.0;

// file "Z:/SIdesign/NS1ellip3W//source/bsimcmg_body.include", line 379
parameter real NPDIBL1 = 0.0;

// file "Z:/SIdesign/NS1ellip3W//source/bsimcmg_body.include", line 380
parameter real PPDIBL1 = 0.0;

// file "Z:/SIdesign/NS1ellip3W//source/bsimcmg_body.include", line 382
parameter real LPDIBL1R = LPDIBL1;

// file "Z:/SIdesign/NS1ellip3W//source/bsimcmg_body.include", line 383
parameter real NPDIBL1R = NPDIBL1;

// file "Z:/SIdesign/NS1ellip3W//source/bsimcmg_body.include", line 384
parameter real PPDIBL1R = PPDIBL1;

// file "Z:/SIdesign/NS1ellip3W//source/bsimcmg_body.include", line 386
parameter real LPDIBL2 = 0.0;

// file "Z:/SIdesign/NS1ellip3W//source/bsimcmg_body.include", line 387
parameter real NPDIBL2 = 0.0;

// file "Z:/SIdesign/NS1ellip3W//source/bsimcmg_body.include", line 388
parameter real PPDIBL2 = 0.0;

// file "Z:/SIdesign/NS1ellip3W//source/bsimcmg_body.include", line 390
parameter real LPDIBL2R = LPDIBL2;

// file "Z:/SIdesign/NS1ellip3W//source/bsimcmg_body.include", line 391
parameter real NPDIBL2R = NPDIBL2;

// file "Z:/SIdesign/NS1ellip3W//source/bsimcmg_body.include", line 392
parameter real PPDIBL2R = PPDIBL2;

// file "Z:/SIdesign/NS1ellip3W//source/bsimcmg_body.include", line 394
parameter real LDROUT = 0.0;

// file "Z:/SIdesign/NS1ellip3W//source/bsimcmg_body.include", line 395
parameter real NDROUT = 0.0;

// file "Z:/SIdesign/NS1ellip3W//source/bsimcmg_body.include", line 396
parameter real PDROUT = 0.0;

// file "Z:/SIdesign/NS1ellip3W//source/bsimcmg_body.include", line 398
parameter real LPVAG = 0.0;

// file "Z:/SIdesign/NS1ellip3W//source/bsimcmg_body.include", line 399
parameter real NPVAG = 0.0;

// file "Z:/SIdesign/NS1ellip3W//source/bsimcmg_body.include", line 400
parameter real PPVAG = 0.0;

// file "Z:/SIdesign/NS1ellip3W//source/bsimcmg_body.include", line 402
parameter real LAIGBINV = 0.0;

// file "Z:/SIdesign/NS1ellip3W//source/bsimcmg_body.include", line 403
parameter real NAIGBINV = 0.0;

// file "Z:/SIdesign/NS1ellip3W//source/bsimcmg_body.include", line 404
parameter real PAIGBINV = 0.0;

// file "Z:/SIdesign/NS1ellip3W//source/bsimcmg_body.include", line 406
parameter real LAIGBINV1 = 0.0;

// file "Z:/SIdesign/NS1ellip3W//source/bsimcmg_body.include", line 407
parameter real NAIGBINV1 = 0.0;

// file "Z:/SIdesign/NS1ellip3W//source/bsimcmg_body.include", line 408
parameter real PAIGBINV1 = 0.0;

// file "Z:/SIdesign/NS1ellip3W//source/bsimcmg_body.include", line 410
parameter real LBIGBINV = 0.0;

// file "Z:/SIdesign/NS1ellip3W//source/bsimcmg_body.include", line 411
parameter real NBIGBINV = 0.0;

// file "Z:/SIdesign/NS1ellip3W//source/bsimcmg_body.include", line 412
parameter real PBIGBINV = 0.0;

// file "Z:/SIdesign/NS1ellip3W//source/bsimcmg_body.include", line 414
parameter real LCIGBINV = 0.0;

// file "Z:/SIdesign/NS1ellip3W//source/bsimcmg_body.include", line 415
parameter real NCIGBINV = 0.0;

// file "Z:/SIdesign/NS1ellip3W//source/bsimcmg_body.include", line 416
parameter real PCIGBINV = 0.0;

// file "Z:/SIdesign/NS1ellip3W//source/bsimcmg_body.include", line 418
parameter real LEIGBINV = 0.0;

// file "Z:/SIdesign/NS1ellip3W//source/bsimcmg_body.include", line 419
parameter real NEIGBINV = 0.0;

// file "Z:/SIdesign/NS1ellip3W//source/bsimcmg_body.include", line 420
parameter real PEIGBINV = 0.0;

// file "Z:/SIdesign/NS1ellip3W//source/bsimcmg_body.include", line 422
parameter real LNIGBINV = 0.0;

// file "Z:/SIdesign/NS1ellip3W//source/bsimcmg_body.include", line 423
parameter real NNIGBINV = 0.0;

// file "Z:/SIdesign/NS1ellip3W//source/bsimcmg_body.include", line 424
parameter real PNIGBINV = 0.0;

// file "Z:/SIdesign/NS1ellip3W//source/bsimcmg_body.include", line 426
parameter real LAIGBACC = 0.0;

// file "Z:/SIdesign/NS1ellip3W//source/bsimcmg_body.include", line 427
parameter real NAIGBACC = 0.0;

// file "Z:/SIdesign/NS1ellip3W//source/bsimcmg_body.include", line 428
parameter real PAIGBACC = 0.0;

// file "Z:/SIdesign/NS1ellip3W//source/bsimcmg_body.include", line 430
parameter real LAIGBACC1 = 0.0;

// file "Z:/SIdesign/NS1ellip3W//source/bsimcmg_body.include", line 431
parameter real NAIGBACC1 = 0.0;

// file "Z:/SIdesign/NS1ellip3W//source/bsimcmg_body.include", line 432
parameter real PAIGBACC1 = 0.0;

// file "Z:/SIdesign/NS1ellip3W//source/bsimcmg_body.include", line 434
parameter real LBIGBACC = 0.0;

// file "Z:/SIdesign/NS1ellip3W//source/bsimcmg_body.include", line 435
parameter real NBIGBACC = 0.0;

// file "Z:/SIdesign/NS1ellip3W//source/bsimcmg_body.include", line 436
parameter real PBIGBACC = 0.0;

// file "Z:/SIdesign/NS1ellip3W//source/bsimcmg_body.include", line 438
parameter real LCIGBACC = 0.0;

// file "Z:/SIdesign/NS1ellip3W//source/bsimcmg_body.include", line 439
parameter real NCIGBACC = 0.0;

// file "Z:/SIdesign/NS1ellip3W//source/bsimcmg_body.include", line 440
parameter real PCIGBACC = 0.0;

// file "Z:/SIdesign/NS1ellip3W//source/bsimcmg_body.include", line 442
parameter real LNIGBACC = 0.0;

// file "Z:/SIdesign/NS1ellip3W//source/bsimcmg_body.include", line 443
parameter real NNIGBACC = 0.0;

// file "Z:/SIdesign/NS1ellip3W//source/bsimcmg_body.include", line 444
parameter real PNIGBACC = 0.0;

// file "Z:/SIdesign/NS1ellip3W//source/bsimcmg_body.include", line 446
parameter real LAIGC = 0.0;

// file "Z:/SIdesign/NS1ellip3W//source/bsimcmg_body.include", line 447
parameter real NAIGC = 0.0;

// file "Z:/SIdesign/NS1ellip3W//source/bsimcmg_body.include", line 448
parameter real PAIGC = 0.0;

// file "Z:/SIdesign/NS1ellip3W//source/bsimcmg_body.include", line 450
parameter real LAIGC1 = 0.0;

// file "Z:/SIdesign/NS1ellip3W//source/bsimcmg_body.include", line 451
parameter real NAIGC1 = 0.0;

// file "Z:/SIdesign/NS1ellip3W//source/bsimcmg_body.include", line 452
parameter real PAIGC1 = 0.0;

// file "Z:/SIdesign/NS1ellip3W//source/bsimcmg_body.include", line 454
parameter real LBIGC = 0.0;

// file "Z:/SIdesign/NS1ellip3W//source/bsimcmg_body.include", line 455
parameter real NBIGC = 0.0;

// file "Z:/SIdesign/NS1ellip3W//source/bsimcmg_body.include", line 456
parameter real PBIGC = 0.0;

// file "Z:/SIdesign/NS1ellip3W//source/bsimcmg_body.include", line 458
parameter real LCIGC = 0.0;

// file "Z:/SIdesign/NS1ellip3W//source/bsimcmg_body.include", line 459
parameter real NCIGC = 0.0;

// file "Z:/SIdesign/NS1ellip3W//source/bsimcmg_body.include", line 460
parameter real PCIGC = 0.0;

// file "Z:/SIdesign/NS1ellip3W//source/bsimcmg_body.include", line 462
parameter real LPIGCD = 0.0;

// file "Z:/SIdesign/NS1ellip3W//source/bsimcmg_body.include", line 463
parameter real NPIGCD = 0.0;

// file "Z:/SIdesign/NS1ellip3W//source/bsimcmg_body.include", line 464
parameter real PPIGCD = 0.0;

// file "Z:/SIdesign/NS1ellip3W//source/bsimcmg_body.include", line 466
parameter real LAIGS = 0.0;

// file "Z:/SIdesign/NS1ellip3W//source/bsimcmg_body.include", line 467
parameter real NAIGS = 0.0;

// file "Z:/SIdesign/NS1ellip3W//source/bsimcmg_body.include", line 468
parameter real PAIGS = 0.0;

// file "Z:/SIdesign/NS1ellip3W//source/bsimcmg_body.include", line 470
parameter real LAIGS1 = 0.0;

// file "Z:/SIdesign/NS1ellip3W//source/bsimcmg_body.include", line 471
parameter real NAIGS1 = 0.0;

// file "Z:/SIdesign/NS1ellip3W//source/bsimcmg_body.include", line 472
parameter real PAIGS1 = 0.0;

// file "Z:/SIdesign/NS1ellip3W//source/bsimcmg_body.include", line 474
parameter real LBIGS = 0.0;

// file "Z:/SIdesign/NS1ellip3W//source/bsimcmg_body.include", line 475
parameter real NBIGS = 0.0;

// file "Z:/SIdesign/NS1ellip3W//source/bsimcmg_body.include", line 476
parameter real PBIGS = 0.0;

// file "Z:/SIdesign/NS1ellip3W//source/bsimcmg_body.include", line 478
parameter real LCIGS = 0.0;

// file "Z:/SIdesign/NS1ellip3W//source/bsimcmg_body.include", line 479
parameter real NCIGS = 0.0;

// file "Z:/SIdesign/NS1ellip3W//source/bsimcmg_body.include", line 480
parameter real PCIGS = 0.0;

// file "Z:/SIdesign/NS1ellip3W//source/bsimcmg_body.include", line 482
parameter real LAIGD = LAIGS;

// file "Z:/SIdesign/NS1ellip3W//source/bsimcmg_body.include", line 483
parameter real NAIGD = NAIGS;

// file "Z:/SIdesign/NS1ellip3W//source/bsimcmg_body.include", line 484
parameter real PAIGD = PAIGS;

// file "Z:/SIdesign/NS1ellip3W//source/bsimcmg_body.include", line 486
parameter real LAIGD1 = LAIGS1;

// file "Z:/SIdesign/NS1ellip3W//source/bsimcmg_body.include", line 487
parameter real NAIGD1 = NAIGS1;

// file "Z:/SIdesign/NS1ellip3W//source/bsimcmg_body.include", line 488
parameter real PAIGD1 = PAIGS1;

// file "Z:/SIdesign/NS1ellip3W//source/bsimcmg_body.include", line 490
parameter real LBIGD = LBIGS;

// file "Z:/SIdesign/NS1ellip3W//source/bsimcmg_body.include", line 491
parameter real NBIGD = NBIGS;

// file "Z:/SIdesign/NS1ellip3W//source/bsimcmg_body.include", line 492
parameter real PBIGD = PBIGS;

// file "Z:/SIdesign/NS1ellip3W//source/bsimcmg_body.include", line 494
parameter real LCIGD = LCIGS;

// file "Z:/SIdesign/NS1ellip3W//source/bsimcmg_body.include", line 495
parameter real NCIGD = NCIGS;

// file "Z:/SIdesign/NS1ellip3W//source/bsimcmg_body.include", line 496
parameter real PCIGD = PCIGS;

// file "Z:/SIdesign/NS1ellip3W//source/bsimcmg_body.include", line 498
parameter real LNTOX = 0.0;

// file "Z:/SIdesign/NS1ellip3W//source/bsimcmg_body.include", line 499
parameter real NNTOX = 0.0;

// file "Z:/SIdesign/NS1ellip3W//source/bsimcmg_body.include", line 500
parameter real PNTOX = 0.0;

// file "Z:/SIdesign/NS1ellip3W//source/bsimcmg_body.include", line 502
parameter real LPOXEDGE = 0.0;

// file "Z:/SIdesign/NS1ellip3W//source/bsimcmg_body.include", line 503
parameter real NPOXEDGE = 0.0;

// file "Z:/SIdesign/NS1ellip3W//source/bsimcmg_body.include", line 504
parameter real PPOXEDGE = 0.0;

// file "Z:/SIdesign/NS1ellip3W//source/bsimcmg_body.include", line 506
parameter real LAGISL = 0.0;

// file "Z:/SIdesign/NS1ellip3W//source/bsimcmg_body.include", line 507
parameter real NAGISL = 0.0;

// file "Z:/SIdesign/NS1ellip3W//source/bsimcmg_body.include", line 508
parameter real PAGISL = 0.0;

// file "Z:/SIdesign/NS1ellip3W//source/bsimcmg_body.include", line 510
parameter real LBGISL = 0.0;

// file "Z:/SIdesign/NS1ellip3W//source/bsimcmg_body.include", line 511
parameter real NBGISL = 0.0;

// file "Z:/SIdesign/NS1ellip3W//source/bsimcmg_body.include", line 512
parameter real PBGISL = 0.0;

// file "Z:/SIdesign/NS1ellip3W//source/bsimcmg_body.include", line 514
parameter real LCGISL = 0.0;

// file "Z:/SIdesign/NS1ellip3W//source/bsimcmg_body.include", line 515
parameter real NCGISL = 0.0;

// file "Z:/SIdesign/NS1ellip3W//source/bsimcmg_body.include", line 516
parameter real PCGISL = 0.0;

// file "Z:/SIdesign/NS1ellip3W//source/bsimcmg_body.include", line 518
parameter real LEGISL = 0.0;

// file "Z:/SIdesign/NS1ellip3W//source/bsimcmg_body.include", line 519
parameter real NEGISL = 0.0;

// file "Z:/SIdesign/NS1ellip3W//source/bsimcmg_body.include", line 520
parameter real PEGISL = 0.0;

// file "Z:/SIdesign/NS1ellip3W//source/bsimcmg_body.include", line 522
parameter real LPGISL = 0.0;

// file "Z:/SIdesign/NS1ellip3W//source/bsimcmg_body.include", line 523
parameter real NPGISL = 0.0;

// file "Z:/SIdesign/NS1ellip3W//source/bsimcmg_body.include", line 524
parameter real PPGISL = 0.0;

// file "Z:/SIdesign/NS1ellip3W//source/bsimcmg_body.include", line 526
parameter real LAGIDL = LAGISL;

// file "Z:/SIdesign/NS1ellip3W//source/bsimcmg_body.include", line 527
parameter real NAGIDL = NAGISL;

// file "Z:/SIdesign/NS1ellip3W//source/bsimcmg_body.include", line 528
parameter real PAGIDL = PAGISL;

// file "Z:/SIdesign/NS1ellip3W//source/bsimcmg_body.include", line 530
parameter real LBGIDL = LBGISL;

// file "Z:/SIdesign/NS1ellip3W//source/bsimcmg_body.include", line 531
parameter real NBGIDL = NBGISL;

// file "Z:/SIdesign/NS1ellip3W//source/bsimcmg_body.include", line 532
parameter real PBGIDL = PBGISL;

// file "Z:/SIdesign/NS1ellip3W//source/bsimcmg_body.include", line 534
parameter real LCGIDL = LCGISL;

// file "Z:/SIdesign/NS1ellip3W//source/bsimcmg_body.include", line 535
parameter real NCGIDL = NCGISL;

// file "Z:/SIdesign/NS1ellip3W//source/bsimcmg_body.include", line 536
parameter real PCGIDL = PCGISL;

// file "Z:/SIdesign/NS1ellip3W//source/bsimcmg_body.include", line 538
parameter real LEGIDL = LEGISL;

// file "Z:/SIdesign/NS1ellip3W//source/bsimcmg_body.include", line 539
parameter real NEGIDL = NEGISL;

// file "Z:/SIdesign/NS1ellip3W//source/bsimcmg_body.include", line 540
parameter real PEGIDL = PEGISL;

// file "Z:/SIdesign/NS1ellip3W//source/bsimcmg_body.include", line 542
parameter real LPGIDL = LPGISL;

// file "Z:/SIdesign/NS1ellip3W//source/bsimcmg_body.include", line 543
parameter real NPGIDL = NPGISL;

// file "Z:/SIdesign/NS1ellip3W//source/bsimcmg_body.include", line 544
parameter real PPGIDL = PPGISL;

// file "Z:/SIdesign/NS1ellip3W//source/bsimcmg_body.include", line 546
parameter real LALPHA0 = 0.0;

// file "Z:/SIdesign/NS1ellip3W//source/bsimcmg_body.include", line 547
parameter real NALPHA0 = 0.0;

// file "Z:/SIdesign/NS1ellip3W//source/bsimcmg_body.include", line 548
parameter real PALPHA0 = 0.0;

// file "Z:/SIdesign/NS1ellip3W//source/bsimcmg_body.include", line 550
parameter real LALPHA1 = 0.0;

// file "Z:/SIdesign/NS1ellip3W//source/bsimcmg_body.include", line 551
parameter real NALPHA1 = 0.0;

// file "Z:/SIdesign/NS1ellip3W//source/bsimcmg_body.include", line 552
parameter real PALPHA1 = 0.0;

// file "Z:/SIdesign/NS1ellip3W//source/bsimcmg_body.include", line 554
parameter real LALPHAII0 = 0.0;

// file "Z:/SIdesign/NS1ellip3W//source/bsimcmg_body.include", line 555
parameter real NALPHAII0 = 0.0;

// file "Z:/SIdesign/NS1ellip3W//source/bsimcmg_body.include", line 556
parameter real PALPHAII0 = 0.0;

// file "Z:/SIdesign/NS1ellip3W//source/bsimcmg_body.include", line 558
parameter real LALPHAII1 = 0.0;

// file "Z:/SIdesign/NS1ellip3W//source/bsimcmg_body.include", line 559
parameter real NALPHAII1 = 0.0;

// file "Z:/SIdesign/NS1ellip3W//source/bsimcmg_body.include", line 560
parameter real PALPHAII1 = 0.0;

// file "Z:/SIdesign/NS1ellip3W//source/bsimcmg_body.include", line 562
parameter real LBETA0 = 0.0;

// file "Z:/SIdesign/NS1ellip3W//source/bsimcmg_body.include", line 563
parameter real NBETA0 = 0.0;

// file "Z:/SIdesign/NS1ellip3W//source/bsimcmg_body.include", line 564
parameter real PBETA0 = 0.0;

// file "Z:/SIdesign/NS1ellip3W//source/bsimcmg_body.include", line 566
parameter real LBETAII0 = 0.0;

// file "Z:/SIdesign/NS1ellip3W//source/bsimcmg_body.include", line 567
parameter real NBETAII0 = 0.0;

// file "Z:/SIdesign/NS1ellip3W//source/bsimcmg_body.include", line 568
parameter real PBETAII0 = 0.0;

// file "Z:/SIdesign/NS1ellip3W//source/bsimcmg_body.include", line 570
parameter real LBETAII1 = 0.0;

// file "Z:/SIdesign/NS1ellip3W//source/bsimcmg_body.include", line 571
parameter real NBETAII1 = 0.0;

// file "Z:/SIdesign/NS1ellip3W//source/bsimcmg_body.include", line 572
parameter real PBETAII1 = 0.0;

// file "Z:/SIdesign/NS1ellip3W//source/bsimcmg_body.include", line 574
parameter real LBETAII2 = 0.0;

// file "Z:/SIdesign/NS1ellip3W//source/bsimcmg_body.include", line 575
parameter real NBETAII2 = 0.0;

// file "Z:/SIdesign/NS1ellip3W//source/bsimcmg_body.include", line 576
parameter real PBETAII2 = 0.0;

// file "Z:/SIdesign/NS1ellip3W//source/bsimcmg_body.include", line 578
parameter real LESATII = 0.0;

// file "Z:/SIdesign/NS1ellip3W//source/bsimcmg_body.include", line 579
parameter real NESATII = 0.0;

// file "Z:/SIdesign/NS1ellip3W//source/bsimcmg_body.include", line 580
parameter real PESATII = 0.0;

// file "Z:/SIdesign/NS1ellip3W//source/bsimcmg_body.include", line 582
parameter real LLII = 0.0;

// file "Z:/SIdesign/NS1ellip3W//source/bsimcmg_body.include", line 583
parameter real NLII = 0.0;

// file "Z:/SIdesign/NS1ellip3W//source/bsimcmg_body.include", line 584
parameter real PLII = 0.0;

// file "Z:/SIdesign/NS1ellip3W//source/bsimcmg_body.include", line 586
parameter real LSII0 = 0.0;

// file "Z:/SIdesign/NS1ellip3W//source/bsimcmg_body.include", line 587
parameter real NSII0 = 0.0;

// file "Z:/SIdesign/NS1ellip3W//source/bsimcmg_body.include", line 588
parameter real PSII0 = 0.0;

// file "Z:/SIdesign/NS1ellip3W//source/bsimcmg_body.include", line 590
parameter real LSII1 = 0.0;

// file "Z:/SIdesign/NS1ellip3W//source/bsimcmg_body.include", line 591
parameter real NSII1 = 0.0;

// file "Z:/SIdesign/NS1ellip3W//source/bsimcmg_body.include", line 592
parameter real PSII1 = 0.0;

// file "Z:/SIdesign/NS1ellip3W//source/bsimcmg_body.include", line 594
parameter real LSII2 = 0.0;

// file "Z:/SIdesign/NS1ellip3W//source/bsimcmg_body.include", line 595
parameter real NSII2 = 0.0;

// file "Z:/SIdesign/NS1ellip3W//source/bsimcmg_body.include", line 596
parameter real PSII2 = 0.0;

// file "Z:/SIdesign/NS1ellip3W//source/bsimcmg_body.include", line 598
parameter real LSIID = 0.0;

// file "Z:/SIdesign/NS1ellip3W//source/bsimcmg_body.include", line 599
parameter real NSIID = 0.0;

// file "Z:/SIdesign/NS1ellip3W//source/bsimcmg_body.include", line 600
parameter real PSIID = 0.0;

// file "Z:/SIdesign/NS1ellip3W//source/bsimcmg_body.include", line 602
parameter real LCFS = 0.0;

// file "Z:/SIdesign/NS1ellip3W//source/bsimcmg_body.include", line 603
parameter real NCFS = 0.0;

// file "Z:/SIdesign/NS1ellip3W//source/bsimcmg_body.include", line 604
parameter real PCFS = 0.0;

// file "Z:/SIdesign/NS1ellip3W//source/bsimcmg_body.include", line 606
parameter real LCFD = LCFS;

// file "Z:/SIdesign/NS1ellip3W//source/bsimcmg_body.include", line 607
parameter real NCFD = NCFS;

// file "Z:/SIdesign/NS1ellip3W//source/bsimcmg_body.include", line 608
parameter real PCFD = PCFS;

// file "Z:/SIdesign/NS1ellip3W//source/bsimcmg_body.include", line 610
parameter real LCOVS = 0.0;

// file "Z:/SIdesign/NS1ellip3W//source/bsimcmg_body.include", line 611
parameter real NCOVS = 0.0;

// file "Z:/SIdesign/NS1ellip3W//source/bsimcmg_body.include", line 612
parameter real PCOVS = 0.0;

// file "Z:/SIdesign/NS1ellip3W//source/bsimcmg_body.include", line 614
parameter real LCOVD = LCOVS;

// file "Z:/SIdesign/NS1ellip3W//source/bsimcmg_body.include", line 615
parameter real NCOVD = NCOVS;

// file "Z:/SIdesign/NS1ellip3W//source/bsimcmg_body.include", line 616
parameter real PCOVD = PCOVS;

// file "Z:/SIdesign/NS1ellip3W//source/bsimcmg_body.include", line 618
parameter real LCGSL = 0.0;

// file "Z:/SIdesign/NS1ellip3W//source/bsimcmg_body.include", line 619
parameter real NCGSL = 0.0;

// file "Z:/SIdesign/NS1ellip3W//source/bsimcmg_body.include", line 620
parameter real PCGSL = 0.0;

// file "Z:/SIdesign/NS1ellip3W//source/bsimcmg_body.include", line 622
parameter real LCGDL = LCGSL;

// file "Z:/SIdesign/NS1ellip3W//source/bsimcmg_body.include", line 623
parameter real NCGDL = NCGSL;

// file "Z:/SIdesign/NS1ellip3W//source/bsimcmg_body.include", line 624
parameter real PCGDL = PCGSL;

// file "Z:/SIdesign/NS1ellip3W//source/bsimcmg_body.include", line 626
parameter real LCKAPPAS = 0.0;

// file "Z:/SIdesign/NS1ellip3W//source/bsimcmg_body.include", line 627
parameter real NCKAPPAS = 0.0;

// file "Z:/SIdesign/NS1ellip3W//source/bsimcmg_body.include", line 628
parameter real PCKAPPAS = 0.0;

// file "Z:/SIdesign/NS1ellip3W//source/bsimcmg_body.include", line 630
parameter real LCKAPPAD = LCKAPPAS;

// file "Z:/SIdesign/NS1ellip3W//source/bsimcmg_body.include", line 631
parameter real NCKAPPAD = NCKAPPAS;

// file "Z:/SIdesign/NS1ellip3W//source/bsimcmg_body.include", line 632
parameter real PCKAPPAD = PCKAPPAS;

// file "Z:/SIdesign/NS1ellip3W//source/bsimcmg_body.include", line 634
parameter real LCGBL = 0.0;

// file "Z:/SIdesign/NS1ellip3W//source/bsimcmg_body.include", line 635
parameter real NCGBL = 0.0;

// file "Z:/SIdesign/NS1ellip3W//source/bsimcmg_body.include", line 636
parameter real PCGBL = 0.0;

// file "Z:/SIdesign/NS1ellip3W//source/bsimcmg_body.include", line 638
parameter real LCKAPPAB = 0.0;

// file "Z:/SIdesign/NS1ellip3W//source/bsimcmg_body.include", line 639
parameter real NCKAPPAB = 0.0;

// file "Z:/SIdesign/NS1ellip3W//source/bsimcmg_body.include", line 640
parameter real PCKAPPAB = 0.0;

// file "Z:/SIdesign/NS1ellip3W//source/bsimcmg_body.include", line 642
parameter real LNTGEN = 0.0;

// file "Z:/SIdesign/NS1ellip3W//source/bsimcmg_body.include", line 643
parameter real NNTGEN = 0.0;

// file "Z:/SIdesign/NS1ellip3W//source/bsimcmg_body.include", line 644
parameter real PNTGEN = 0.0;

// file "Z:/SIdesign/NS1ellip3W//source/bsimcmg_body.include", line 646
parameter real LAIGEN = 0.0;

// file "Z:/SIdesign/NS1ellip3W//source/bsimcmg_body.include", line 647
parameter real NAIGEN = 0.0;

// file "Z:/SIdesign/NS1ellip3W//source/bsimcmg_body.include", line 648
parameter real PAIGEN = 0.0;

// file "Z:/SIdesign/NS1ellip3W//source/bsimcmg_body.include", line 650
parameter real LBIGEN = 0.0;

// file "Z:/SIdesign/NS1ellip3W//source/bsimcmg_body.include", line 651
parameter real NBIGEN = 0.0;

// file "Z:/SIdesign/NS1ellip3W//source/bsimcmg_body.include", line 652
parameter real PBIGEN = 0.0;

// file "Z:/SIdesign/NS1ellip3W//source/bsimcmg_body.include", line 654
parameter real LXRCRG1 = 0.0;

// file "Z:/SIdesign/NS1ellip3W//source/bsimcmg_body.include", line 655
parameter real NXRCRG1 = 0.0;

// file "Z:/SIdesign/NS1ellip3W//source/bsimcmg_body.include", line 656
parameter real PXRCRG1 = 0.0;

// file "Z:/SIdesign/NS1ellip3W//source/bsimcmg_body.include", line 658
parameter real LXRCRG2 = 0.0;

// file "Z:/SIdesign/NS1ellip3W//source/bsimcmg_body.include", line 659
parameter real NXRCRG2 = 0.0;

// file "Z:/SIdesign/NS1ellip3W//source/bsimcmg_body.include", line 660
parameter real PXRCRG2 = 0.0;

// file "Z:/SIdesign/NS1ellip3W//source/bsimcmg_body.include", line 662
parameter real LUTE = 0.0;

// file "Z:/SIdesign/NS1ellip3W//source/bsimcmg_body.include", line 663
parameter real NUTE = 0.0;

// file "Z:/SIdesign/NS1ellip3W//source/bsimcmg_body.include", line 664
parameter real PUTE = 0.0;

// file "Z:/SIdesign/NS1ellip3W//source/bsimcmg_body.include", line 666
parameter real LUTER = LUTE;

// file "Z:/SIdesign/NS1ellip3W//source/bsimcmg_body.include", line 667
parameter real NUTER = NUTE;

// file "Z:/SIdesign/NS1ellip3W//source/bsimcmg_body.include", line 668
parameter real PUTER = PUTE;

// file "Z:/SIdesign/NS1ellip3W//source/bsimcmg_body.include", line 670
parameter real LUTL = 0.0;

// file "Z:/SIdesign/NS1ellip3W//source/bsimcmg_body.include", line 671
parameter real NUTL = 0.0;

// file "Z:/SIdesign/NS1ellip3W//source/bsimcmg_body.include", line 672
parameter real PUTL = 0.0;

// file "Z:/SIdesign/NS1ellip3W//source/bsimcmg_body.include", line 674
parameter real LUTLR = LUTL;

// file "Z:/SIdesign/NS1ellip3W//source/bsimcmg_body.include", line 675
parameter real NUTLR = NUTL;

// file "Z:/SIdesign/NS1ellip3W//source/bsimcmg_body.include", line 676
parameter real PUTLR = PUTL;

// file "Z:/SIdesign/NS1ellip3W//source/bsimcmg_body.include", line 678
parameter real LEMOBT = 0.0;

// file "Z:/SIdesign/NS1ellip3W//source/bsimcmg_body.include", line 679
parameter real NEMOBT = 0.0;

// file "Z:/SIdesign/NS1ellip3W//source/bsimcmg_body.include", line 680
parameter real PEMOBT = 0.0;

// file "Z:/SIdesign/NS1ellip3W//source/bsimcmg_body.include", line 682
parameter real LUA1 = 0.0;

// file "Z:/SIdesign/NS1ellip3W//source/bsimcmg_body.include", line 683
parameter real NUA1 = 0.0;

// file "Z:/SIdesign/NS1ellip3W//source/bsimcmg_body.include", line 684
parameter real PUA1 = 0.0;

// file "Z:/SIdesign/NS1ellip3W//source/bsimcmg_body.include", line 686
parameter real LUA1R = LUA1;

// file "Z:/SIdesign/NS1ellip3W//source/bsimcmg_body.include", line 687
parameter real NUA1R = NUA1;

// file "Z:/SIdesign/NS1ellip3W//source/bsimcmg_body.include", line 688
parameter real PUA1R = PUA1;

// file "Z:/SIdesign/NS1ellip3W//source/bsimcmg_body.include", line 690
parameter real LUC1 = 0.0;

// file "Z:/SIdesign/NS1ellip3W//source/bsimcmg_body.include", line 691
parameter real NUC1 = 0.0;

// file "Z:/SIdesign/NS1ellip3W//source/bsimcmg_body.include", line 692
parameter real PUC1 = 0.0;

// file "Z:/SIdesign/NS1ellip3W//source/bsimcmg_body.include", line 694
parameter real LUC1R = LUC1;

// file "Z:/SIdesign/NS1ellip3W//source/bsimcmg_body.include", line 695
parameter real NUC1R = NUC1;

// file "Z:/SIdesign/NS1ellip3W//source/bsimcmg_body.include", line 696
parameter real PUC1R = PUC1;

// file "Z:/SIdesign/NS1ellip3W//source/bsimcmg_body.include", line 698
parameter real LUD1 = 0.0;

// file "Z:/SIdesign/NS1ellip3W//source/bsimcmg_body.include", line 699
parameter real NUD1 = 0.0;

// file "Z:/SIdesign/NS1ellip3W//source/bsimcmg_body.include", line 700
parameter real PUD1 = 0.0;

// file "Z:/SIdesign/NS1ellip3W//source/bsimcmg_body.include", line 702
parameter real LUD1R = LUD1;

// file "Z:/SIdesign/NS1ellip3W//source/bsimcmg_body.include", line 703
parameter real NUD1R = NUD1;

// file "Z:/SIdesign/NS1ellip3W//source/bsimcmg_body.include", line 704
parameter real PUD1R = PUD1;

// file "Z:/SIdesign/NS1ellip3W//source/bsimcmg_body.include", line 706
parameter real LUCSTE = 0.0;

// file "Z:/SIdesign/NS1ellip3W//source/bsimcmg_body.include", line 707
parameter real NUCSTE = 0.0;

// file "Z:/SIdesign/NS1ellip3W//source/bsimcmg_body.include", line 708
parameter real PUCSTE = 0.0;

// file "Z:/SIdesign/NS1ellip3W//source/bsimcmg_body.include", line 710
parameter real LPTWGT = 0.0;

// file "Z:/SIdesign/NS1ellip3W//source/bsimcmg_body.include", line 711
parameter real NPTWGT = 0.0;

// file "Z:/SIdesign/NS1ellip3W//source/bsimcmg_body.include", line 712
parameter real PPTWGT = 0.0;

// file "Z:/SIdesign/NS1ellip3W//source/bsimcmg_body.include", line 714
parameter real LAT = 0.0;

// file "Z:/SIdesign/NS1ellip3W//source/bsimcmg_body.include", line 715
parameter real NAT = 0.0;

// file "Z:/SIdesign/NS1ellip3W//source/bsimcmg_body.include", line 716
parameter real PAT = 0.0;

// file "Z:/SIdesign/NS1ellip3W//source/bsimcmg_body.include", line 718
parameter real LATR = LAT;

// file "Z:/SIdesign/NS1ellip3W//source/bsimcmg_body.include", line 719
parameter real NATR = NAT;

// file "Z:/SIdesign/NS1ellip3W//source/bsimcmg_body.include", line 720
parameter real PATR = PAT;

// file "Z:/SIdesign/NS1ellip3W//source/bsimcmg_body.include", line 722
parameter real LATCV = 0.0;

// file "Z:/SIdesign/NS1ellip3W//source/bsimcmg_body.include", line 723
parameter real NATCV = 0.0;

// file "Z:/SIdesign/NS1ellip3W//source/bsimcmg_body.include", line 724
parameter real PATCV = 0.0;

// file "Z:/SIdesign/NS1ellip3W//source/bsimcmg_body.include", line 726
parameter real LSTTHETASAT = 0.0;

// file "Z:/SIdesign/NS1ellip3W//source/bsimcmg_body.include", line 727
parameter real NSTTHETASAT = 0.0;

// file "Z:/SIdesign/NS1ellip3W//source/bsimcmg_body.include", line 728
parameter real PSTTHETASAT = 0.0;

// file "Z:/SIdesign/NS1ellip3W//source/bsimcmg_body.include", line 730
parameter real LPRT = 0.0;

// file "Z:/SIdesign/NS1ellip3W//source/bsimcmg_body.include", line 731
parameter real NPRT = 0.0;

// file "Z:/SIdesign/NS1ellip3W//source/bsimcmg_body.include", line 732
parameter real PPRT = 0.0;

// file "Z:/SIdesign/NS1ellip3W//source/bsimcmg_body.include", line 734
parameter real LKT1 = 0.0;

// file "Z:/SIdesign/NS1ellip3W//source/bsimcmg_body.include", line 735
parameter real NKT1 = 0.0;

// file "Z:/SIdesign/NS1ellip3W//source/bsimcmg_body.include", line 736
parameter real PKT1 = 0.0;

// file "Z:/SIdesign/NS1ellip3W//source/bsimcmg_body.include", line 738
parameter real LTSS = 0.0;

// file "Z:/SIdesign/NS1ellip3W//source/bsimcmg_body.include", line 739
parameter real NTSS = 0.0;

// file "Z:/SIdesign/NS1ellip3W//source/bsimcmg_body.include", line 740
parameter real PTSS = 0.0;

// file "Z:/SIdesign/NS1ellip3W//source/bsimcmg_body.include", line 742
parameter real LIIT = 0.0;

// file "Z:/SIdesign/NS1ellip3W//source/bsimcmg_body.include", line 743
parameter real NIIT = 0.0;

// file "Z:/SIdesign/NS1ellip3W//source/bsimcmg_body.include", line 744
parameter real PIIT = 0.0;

// file "Z:/SIdesign/NS1ellip3W//source/bsimcmg_body.include", line 746
parameter real LTII = 0.0;

// file "Z:/SIdesign/NS1ellip3W//source/bsimcmg_body.include", line 747
parameter real NTII = 0.0;

// file "Z:/SIdesign/NS1ellip3W//source/bsimcmg_body.include", line 748
parameter real PTII = 0.0;

// file "Z:/SIdesign/NS1ellip3W//source/bsimcmg_body.include", line 750
parameter real LTGIDL = 0.0;

// file "Z:/SIdesign/NS1ellip3W//source/bsimcmg_body.include", line 751
parameter real NTGIDL = 0.0;

// file "Z:/SIdesign/NS1ellip3W//source/bsimcmg_body.include", line 752
parameter real PTGIDL = 0.0;

// file "Z:/SIdesign/NS1ellip3W//source/bsimcmg_body.include", line 754
parameter real LIGT = 0.0;

// file "Z:/SIdesign/NS1ellip3W//source/bsimcmg_body.include", line 755
parameter real NIGT = 0.0;

// file "Z:/SIdesign/NS1ellip3W//source/bsimcmg_body.include", line 756
parameter real PIGT = 0.0;

// file "Z:/SIdesign/NS1ellip3W//source/bsimcmg_body.include", line 722
real WEFF;

// file "Z:/SIdesign/NS1ellip3W//source/bsimcmg_body.include", line 723
real LEFF;

// file "Z:/SIdesign/NS1ellip3W//source/bsimcmg_body.include", line 724
real WEFFCV;

// file "Z:/SIdesign/NS1ellip3W//source/bsimcmg_body.include", line 725
real LEFFCV;

// file "Z:/SIdesign/NS1ellip3W//source/bsimcmg_body.include", line 726
real IDS;

// file "Z:/SIdesign/NS1ellip3W//source/bsimcmg_body.include", line 727
real IDEFF;

// file "Z:/SIdesign/NS1ellip3W//source/bsimcmg_body.include", line 728
real ISEFF;

// file "Z:/SIdesign/NS1ellip3W//source/bsimcmg_body.include", line 729
real IGTOT;

// file "Z:/SIdesign/NS1ellip3W//source/bsimcmg_body.include", line 730
real IDSGEN;

// file "Z:/SIdesign/NS1ellip3W//source/bsimcmg_body.include", line 731
real III;

// file "Z:/SIdesign/NS1ellip3W//source/bsimcmg_body.include", line 732
real IGS;

// file "Z:/SIdesign/NS1ellip3W//source/bsimcmg_body.include", line 733
real IGD;

// file "Z:/SIdesign/NS1ellip3W//source/bsimcmg_body.include", line 734
real IGCS;

// file "Z:/SIdesign/NS1ellip3W//source/bsimcmg_body.include", line 735
real IGCD;

// file "Z:/SIdesign/NS1ellip3W//source/bsimcmg_body.include", line 736
real IGBS;

// file "Z:/SIdesign/NS1ellip3W//source/bsimcmg_body.include", line 737
real IGBD;

// file "Z:/SIdesign/NS1ellip3W//source/bsimcmg_body.include", line 738
real IGIDL;

// file "Z:/SIdesign/NS1ellip3W//source/bsimcmg_body.include", line 739
real IGISL;

// file "Z:/SIdesign/NS1ellip3W//source/bsimcmg_body.include", line 740
real IJSB;

// file "Z:/SIdesign/NS1ellip3W//source/bsimcmg_body.include", line 741
real IJDB;

// file "Z:/SIdesign/NS1ellip3W//source/bsimcmg_body.include", line 742
real ISUB;

// file "Z:/SIdesign/NS1ellip3W//source/bsimcmg_body.include", line 743
real BETA;

// file "Z:/SIdesign/NS1ellip3W//source/bsimcmg_body.include", line 744
real VTH;

// file "Z:/SIdesign/NS1ellip3W//source/bsimcmg_body.include", line 745
real VDSSAT;

// file "Z:/SIdesign/NS1ellip3W//source/bsimcmg_body.include", line 746
real VFB;

// file "Z:/SIdesign/NS1ellip3W//source/bsimcmg_body.include", line 747
real GM;

// file "Z:/SIdesign/NS1ellip3W//source/bsimcmg_body.include", line 748
real GDS;

// file "Z:/SIdesign/NS1ellip3W//source/bsimcmg_body.include", line 749
real GMBS;

// file "Z:/SIdesign/NS1ellip3W//source/bsimcmg_body.include", line 750
real QGI;

// file "Z:/SIdesign/NS1ellip3W//source/bsimcmg_body.include", line 751
real QDI;

// file "Z:/SIdesign/NS1ellip3W//source/bsimcmg_body.include", line 752
real QSI;

// file "Z:/SIdesign/NS1ellip3W//source/bsimcmg_body.include", line 753
real QBI;

// file "Z:/SIdesign/NS1ellip3W//source/bsimcmg_body.include", line 754
real QG;

// file "Z:/SIdesign/NS1ellip3W//source/bsimcmg_body.include", line 755
real QD;

// file "Z:/SIdesign/NS1ellip3W//source/bsimcmg_body.include", line 756
real QS;

// file "Z:/SIdesign/NS1ellip3W//source/bsimcmg_body.include", line 757
real QB;

// file "Z:/SIdesign/NS1ellip3W//source/bsimcmg_body.include", line 758
real CGGI;

// file "Z:/SIdesign/NS1ellip3W//source/bsimcmg_body.include", line 759
real CGSI;

// file "Z:/SIdesign/NS1ellip3W//source/bsimcmg_body.include", line 760
real CGDI;

// file "Z:/SIdesign/NS1ellip3W//source/bsimcmg_body.include", line 761
real CGEI;

// file "Z:/SIdesign/NS1ellip3W//source/bsimcmg_body.include", line 762
real CDGI;

// file "Z:/SIdesign/NS1ellip3W//source/bsimcmg_body.include", line 763
real CDDI;

// file "Z:/SIdesign/NS1ellip3W//source/bsimcmg_body.include", line 764
real CDSI;

// file "Z:/SIdesign/NS1ellip3W//source/bsimcmg_body.include", line 765
real CDEI;

// file "Z:/SIdesign/NS1ellip3W//source/bsimcmg_body.include", line 766
real CSGI;

// file "Z:/SIdesign/NS1ellip3W//source/bsimcmg_body.include", line 767
real CSDI;

// file "Z:/SIdesign/NS1ellip3W//source/bsimcmg_body.include", line 768
real CSSI;

// file "Z:/SIdesign/NS1ellip3W//source/bsimcmg_body.include", line 769
real CSEI;

// file "Z:/SIdesign/NS1ellip3W//source/bsimcmg_body.include", line 770
real CEGI;

// file "Z:/SIdesign/NS1ellip3W//source/bsimcmg_body.include", line 771
real CEDI;

// file "Z:/SIdesign/NS1ellip3W//source/bsimcmg_body.include", line 772
real CESI;

// file "Z:/SIdesign/NS1ellip3W//source/bsimcmg_body.include", line 773
real CEEI;

// file "Z:/SIdesign/NS1ellip3W//source/bsimcmg_body.include", line 774
real CGG;

// file "Z:/SIdesign/NS1ellip3W//source/bsimcmg_body.include", line 775
real CGS;

// file "Z:/SIdesign/NS1ellip3W//source/bsimcmg_body.include", line 776
real CGD;

// file "Z:/SIdesign/NS1ellip3W//source/bsimcmg_body.include", line 777
real CGE;

// file "Z:/SIdesign/NS1ellip3W//source/bsimcmg_body.include", line 778
real CDG;

// file "Z:/SIdesign/NS1ellip3W//source/bsimcmg_body.include", line 779
real CDD;

// file "Z:/SIdesign/NS1ellip3W//source/bsimcmg_body.include", line 780
real CDS;

// file "Z:/SIdesign/NS1ellip3W//source/bsimcmg_body.include", line 781
real CDE;

// file "Z:/SIdesign/NS1ellip3W//source/bsimcmg_body.include", line 782
real CSG;

// file "Z:/SIdesign/NS1ellip3W//source/bsimcmg_body.include", line 783
real CSD;

// file "Z:/SIdesign/NS1ellip3W//source/bsimcmg_body.include", line 784
real CSS;

// file "Z:/SIdesign/NS1ellip3W//source/bsimcmg_body.include", line 785
real CSE;

// file "Z:/SIdesign/NS1ellip3W//source/bsimcmg_body.include", line 786
real CEG;

// file "Z:/SIdesign/NS1ellip3W//source/bsimcmg_body.include", line 787
real CED;

// file "Z:/SIdesign/NS1ellip3W//source/bsimcmg_body.include", line 788
real CES;

// file "Z:/SIdesign/NS1ellip3W//source/bsimcmg_body.include", line 789
real CEE;

// file "Z:/SIdesign/NS1ellip3W//source/bsimcmg_body.include", line 790
real CGSEXT;

// file "Z:/SIdesign/NS1ellip3W//source/bsimcmg_body.include", line 791
real CGDEXT;

// file "Z:/SIdesign/NS1ellip3W//source/bsimcmg_body.include", line 792
real CGBOV;

// file "Z:/SIdesign/NS1ellip3W//source/bsimcmg_body.include", line 793
real CJST;

// file "Z:/SIdesign/NS1ellip3W//source/bsimcmg_body.include", line 794
real CJDT;

// file "Z:/SIdesign/NS1ellip3W//source/bsimcmg_body.include", line 795
real RSGEO;

// file "Z:/SIdesign/NS1ellip3W//source/bsimcmg_body.include", line 796
real RDGEO;

// file "Z:/SIdesign/NS1ellip3W//source/bsimcmg_body.include", line 797
real CFGEO;

// file "Z:/SIdesign/NS1ellip3W//source/bsimcmg_body.include", line 798
real T_TOTAL_K;

// file "Z:/SIdesign/NS1ellip3W//source/bsimcmg_body.include", line 799
real T_TOTAL_C;

// file "Z:/SIdesign/NS1ellip3W//source/bsimcmg_body.include", line 800
real T_DELTA_SH;

// file "Z:/SIdesign/NS1ellip3W//source/bsimcmg_body.include", line 803
real IGBACC;

// file "Z:/SIdesign/NS1ellip3W//source/bsimcmg_body.include", line 804
real IGBINV;

// file "Z:/SIdesign/NS1ellip3W//source/bsimcmg_body.include", line 805
real DIDSDVG;

// file "Z:/SIdesign/NS1ellip3W//source/bsimcmg_body.include", line 806
real DIDSDVS;

// file "Z:/SIdesign/NS1ellip3W//source/bsimcmg_body.include", line 807
real DIDSDVD;

// file "Z:/SIdesign/NS1ellip3W//source/bsimcmg_body.include", line 808
real DIGSDVG;

// file "Z:/SIdesign/NS1ellip3W//source/bsimcmg_body.include", line 809
real DIGSDVS;

// file "Z:/SIdesign/NS1ellip3W//source/bsimcmg_body.include", line 810
real DIGSDVD;

// file "Z:/SIdesign/NS1ellip3W//source/bsimcmg_body.include", line 811
real DIGDDVG;

// file "Z:/SIdesign/NS1ellip3W//source/bsimcmg_body.include", line 812
real DIGDDVS;

// file "Z:/SIdesign/NS1ellip3W//source/bsimcmg_body.include", line 813
real DIGDDVD;

// file "Z:/SIdesign/NS1ellip3W//source/bsimcmg_body.include", line 814
real DIIIDVG;

// file "Z:/SIdesign/NS1ellip3W//source/bsimcmg_body.include", line 815
real DIIIDVS;

// file "Z:/SIdesign/NS1ellip3W//source/bsimcmg_body.include", line 816
real DIIIDVD;

// file "Z:/SIdesign/NS1ellip3W//source/bsimcmg_body.include", line 817
real DIGIDLDVG;

// file "Z:/SIdesign/NS1ellip3W//source/bsimcmg_body.include", line 818
real DIGIDLDVS;

// file "Z:/SIdesign/NS1ellip3W//source/bsimcmg_body.include", line 819
real DIGIDLDVD;

// file "Z:/SIdesign/NS1ellip3W//source/bsimcmg_body.include", line 820
real DIGISLDVG;

// file "Z:/SIdesign/NS1ellip3W//source/bsimcmg_body.include", line 821
real DIGISLDVS;

// file "Z:/SIdesign/NS1ellip3W//source/bsimcmg_body.include", line 822
real DIGISLDVD;

// file "Z:/SIdesign/NS1ellip3W//source/bsimcmg_body.include", line 825
real CGT;

// file "Z:/SIdesign/NS1ellip3W//source/bsimcmg_body.include", line 826
real CST;

// file "Z:/SIdesign/NS1ellip3W//source/bsimcmg_body.include", line 827
real CDT;

// file "Z:/SIdesign/NS1ellip3W//source/bsimcmg_body.include", line 828
real DIDSDVTH;

// file "Z:/SIdesign/NS1ellip3W//source/bsimcmg_body.include", line 829
real DIGSDVTH;

// file "Z:/SIdesign/NS1ellip3W//source/bsimcmg_body.include", line 830
real DIGDDVTH;

// file "Z:/SIdesign/NS1ellip3W//source/bsimcmg_body.include", line 831
real DIIIDVTH;

// file "Z:/SIdesign/NS1ellip3W//source/bsimcmg_body.include", line 832
real DIGIDLDVTH;

// file "Z:/SIdesign/NS1ellip3W//source/bsimcmg_body.include", line 833
real DIGISLDVTH;

// file "Z:/SIdesign/NS1ellip3W//source/bsimcmg_body.include", line 834
real DITHDVTH;

// file "Z:/SIdesign/NS1ellip3W//source/bsimcmg_body.include", line 837
real ITH;

// file "Z:/SIdesign/NS1ellip3W//source/bsimcmg_body.include", line 838
real DITHDVG;

// file "Z:/SIdesign/NS1ellip3W//source/bsimcmg_body.include", line 839
real DITHDVS;

// file "Z:/SIdesign/NS1ellip3W//source/bsimcmg_body.include", line 840
real DITHDVD;

// file "Z:/SIdesign/NS1ellip3W//source/bsimcmg_body.include", line 845
integer devsign;

// file "Z:/SIdesign/NS1ellip3W//source/bsimcmg_body.include", line 847
real NFINtotal;

// file "Z:/SIdesign/NS1ellip3W//source/bsimcmg_body.include", line 848
real DevTemp;

// file "Z:/SIdesign/NS1ellip3W//source/bsimcmg_body.include", line 849
real ids0, ids0_ov_dqi, ids, vgs, vds, vdsx, sigvds, vch, etaiv;

// file "Z:/SIdesign/NS1ellip3W//source/bsimcmg_body.include", line 850
real vgs_noswap, vds_noswap, vgd_noswap;

// file "Z:/SIdesign/NS1ellip3W//source/bsimcmg_body.include", line 851
real qd, qg, qs, qb;

// file "Z:/SIdesign/NS1ellip3W//source/bsimcmg_body.include", line 852
real ni, epssub, epssp, epsratio, Eg, Eg0, Nc;

// file "Z:/SIdesign/NS1ellip3W//source/bsimcmg_body.include", line 853
real Lg, deltaL, deltaL1, deltaLCV, Leff, Leff1, LeffCV, LeffCV_acc, Weff0, WeffCV0;

// file "Z:/SIdesign/NS1ellip3W//source/bsimcmg_body.include", line 854
real cox, cdsc, cbox;

// file "Z:/SIdesign/NS1ellip3W//source/bsimcmg_body.include", line 855
real nbody, phib, deltaPhi;

// file "Z:/SIdesign/NS1ellip3W//source/bsimcmg_body.include", line 856
real T0, T1, T2, T3, T4, T4a, T5, T6, T7, T8, T9;

// file "Z:/SIdesign/NS1ellip3W//source/bsimcmg_body.include", line 857
real Vtm, Vtm0, nVtm;

// file "Z:/SIdesign/NS1ellip3W//source/bsimcmg_body.include", line 858
real beta, beta0;

// file "Z:/SIdesign/NS1ellip3W//source/bsimcmg_body.include", line 859
real wf, wr;

// file "Z:/SIdesign/NS1ellip3W//source/bsimcmg_body.include", line 862
real Tnom, TRatio, dvth_temp, delTemp, ThetaSS;

// file "Z:/SIdesign/NS1ellip3W//source/bsimcmg_body.include", line 863
real K0_t, K0SI_t, K2SI_t, K1_t, K2SAT_t, A1_t, A2_t;

// file "Z:/SIdesign/NS1ellip3W//source/bsimcmg_body.include", line 864
real AIGBINV_t, AIGBACC_t, AIGC_t, AIGS_t, AIGD_t;

// file "Z:/SIdesign/NS1ellip3W//source/bsimcmg_body.include", line 865
real BETA0_t, SII0_t, BGISL_t, BGIDL_t, igtemp, PTWG_t, PTWGR_t;

// file "Z:/SIdesign/NS1ellip3W//source/bsimcmg_body.include", line 866
real ALPHA0_t, ALPHA1_t, ALPHAII0_t, ALPHAII1_t;

// file "Z:/SIdesign/NS1ellip3W//source/bsimcmg_body.include", line 867
real CJS_t, CJSWS_t, CJSWGD_t, CJD_t, CJSWD_t, CJSWGS_t;

// file "Z:/SIdesign/NS1ellip3W//source/bsimcmg_body.include", line 868
real PBS_t, PBSWS_t, PBSWGS_t, PBD_t, PBSWD_t, PBSWGD_t;

// file "Z:/SIdesign/NS1ellip3W//source/bsimcmg_body.include", line 869
real JSS_t, JSWS_t, JSWGS_t, JSD_t, JSWD_t, JSWGD_t;

// file "Z:/SIdesign/NS1ellip3W//source/bsimcmg_body.include", line 870
real JTSS_t, JTSD_t, JTSSWS_t, JTSSWD_t, JTSSWGS_t, JTSSWGD_t;

// file "Z:/SIdesign/NS1ellip3W//source/bsimcmg_body.include", line 871
real NJTS_t, NJTSD_t, NJTSSW_t, NJTSSWD_t, NJTSSWG_t, NJTSSWGD_t;

// file "Z:/SIdesign/NS1ellip3W//source/bsimcmg_body.include", line 872
real K2_t;

// file "Z:/SIdesign/NS1ellip3W//source/bsimcmg_body.include", line 873
real K0SISAT_t, K2SISAT_t;

// file "Z:/SIdesign/NS1ellip3W//source/bsimcmg_body.include", line 876
real q0;

// file "Z:/SIdesign/NS1ellip3W//source/bsimcmg_body.include", line 877
real T10, T11, T12;

// file "Z:/SIdesign/NS1ellip3W//source/bsimcmg_body.include", line 878
real e0, e1, e2;

// file "Z:/SIdesign/NS1ellip3W//source/bsimcmg_body.include", line 881
real vgsfb, vgsfbeff;

// file "Z:/SIdesign/NS1ellip3W//source/bsimcmg_body.include", line 884
real ETA0_t, ETA0R_t;

// file "Z:/SIdesign/NS1ellip3W//source/bsimcmg_body.include", line 885
real scl, vbi, phist, dvth_vtroll, dvth_dibl, dvth_rsce, dvth_all;

// file "Z:/SIdesign/NS1ellip3W//source/bsimcmg_body.include", line 886
real tmp, Theta_SCE, Theta_SW, Theta_DIBL, Theta_RSCE, Theta_DITS;

// file "Z:/SIdesign/NS1ellip3W//source/bsimcmg_body.include", line 889
real Mnud;

// file "Z:/SIdesign/NS1ellip3W//source/bsimcmg_body.include", line 892
real ves, vesx, vesmax, veseff;

// file "Z:/SIdesign/NS1ellip3W//source/bsimcmg_body.include", line 893
real Mob;

// file "Z:/SIdesign/NS1ellip3W//source/bsimcmg_body.include", line 896
real coxeff, Tcen0, Tcen, dvch_qm, MTcen;

// file "Z:/SIdesign/NS1ellip3W//source/bsimcmg_body.include", line 897
real E0, E0prime, E1, E1prime, mx, mxprime, md, mdprime;

// file "Z:/SIdesign/NS1ellip3W//source/bsimcmg_body.include", line 898
real gprime, gfactor, gam0, gam1, kT;

// file "Z:/SIdesign/NS1ellip3W//source/bsimcmg_body.include", line 901
real Vdseff, qis, qid, qbs, Dmobs;

// file "Z:/SIdesign/NS1ellip3W//source/bsimcmg_body.include", line 904
real qia, qia2, qba, dqi;

// file "Z:/SIdesign/NS1ellip3W//source/bsimcmg_body.include", line 905
real qb0;

// file "Z:/SIdesign/NS1ellip3W//source/bsimcmg_body.include", line 906
real eta_mu, eta_mu_cv, Eeffm, Eeffm_cv, Dmob, Dmob_cv, u0, ueff, u0_a, u0r;

// file "Z:/SIdesign/NS1ellip3W//source/bsimcmg_body.include", line 907
real UA_t, UAR_t, UC_t, UCR_t, UCS_t, UD_t, UDR_t, U0_t, U0R_t, ETAMOB_t, Eeffs, EeffFactor;

// file "Z:/SIdesign/NS1ellip3W//source/bsimcmg_body.include", line 909
real Dr, WeffWRFactor;

// file "Z:/SIdesign/NS1ellip3W//source/bsimcmg_body.include", line 910
real RSourceGeo, RDrainGeo;

// file "Z:/SIdesign/NS1ellip3W//source/bsimcmg_body.include", line 911
real RDSWMIN_i, RDWMIN_i, RSWMIN_i;

// file "Z:/SIdesign/NS1ellip3W//source/bsimcmg_body.include", line 912
real Rdrain, Rsource;

// file "Z:/SIdesign/NS1ellip3W//source/bsimcmg_body.include", line 914
real rdstemp, Rdsi, Rdss;

// file "Z:/SIdesign/NS1ellip3W//source/bsimcmg_body.include", line 915
real RSDR_t, RSDRR_t, RDDR_t, RDDRR_t;

// file "Z:/SIdesign/NS1ellip3W//source/bsimcmg_body.include", line 917
real DIBLfactor, PVAGfactor, diffVds, VaDIBL, Vgst2Vtm, Moc, Mclm;

// file "Z:/SIdesign/NS1ellip3W//source/bsimcmg_body.include", line 918
real MclmCV, inv_MclmCV;

// file "Z:/SIdesign/NS1ellip3W//source/bsimcmg_body.include", line 920
real Dvsat, Vdsat, inv_MEXP, DvsatCV, Nsat;

// file "Z:/SIdesign/NS1ellip3W//source/bsimcmg_body.include", line 921
real VSAT_t, VSAT1_t, VSAT1R_t, VSATCV_t, MEXP_t, MEXPR_t, Esat, EsatL, Esat1, Esat1L, EsatCV, EsatCVL;

// file "Z:/SIdesign/NS1ellip3W//source/bsimcmg_body.include", line 922
real WVCox, Ta, Tb, Tc;

// file "Z:/SIdesign/NS1ellip3W//source/bsimcmg_body.include", line 925
real VSAT1_a, MEXP_a, PTWG_a, RSDR_a, RDDR_a, PDIBL1_a, VSAT_a;

// file "Z:/SIdesign/NS1ellip3W//source/bsimcmg_body.include", line 928
real mu_max, mu_rsd, rhorsd, afin, thetarsp;

// file "Z:/SIdesign/NS1ellip3W//source/bsimcmg_body.include", line 929
real Rsp, lt, arsd_total, prsd_total, alpha;

// file "Z:/SIdesign/NS1ellip3W//source/bsimcmg_body.include", line 930
real eta, RrsdTML, Rrsdside, Rrsd;

// file "Z:/SIdesign/NS1ellip3W//source/bsimcmg_body.include", line 931
real Rdsgeo, Arsd, Prsd;

// file "Z:/SIdesign/NS1ellip3W//source/bsimcmg_body.include", line 934
real Hg, Wg, Trsd, Hrsd, Cgg_top, Cgg_side, Cfr_geo, Acorner, Ccorner;

// file "Z:/SIdesign/NS1ellip3W//source/bsimcmg_body.include", line 938
real ggeltd, Rgeltd;

// file "Z:/SIdesign/NS1ellip3W//source/bsimcmg_body.include", line 942
real Vaux_Igbinv, igbinv, igsd_mult, igsd_mult0, igbs, igbd;

// file "Z:/SIdesign/NS1ellip3W//source/bsimcmg_body.include", line 943
real Voxacc, Vaux_Igbacc, vfbzb, igbacc;

// file "Z:/SIdesign/NS1ellip3W//source/bsimcmg_body.include", line 944
real igcs, igcd, igc0, Vdseffx, T1_exp;

// file "Z:/SIdesign/NS1ellip3W//source/bsimcmg_body.include", line 945
real igisl, igidl, vfbsd, igs, igd, vgs_eff, vgd_eff;

// file "Z:/SIdesign/NS1ellip3W//source/bsimcmg_body.include", line 946
real Aechvb, Bechvb, Toxratio, Toxratioedge;

// file "Z:/SIdesign/NS1ellip3W//source/bsimcmg_body.include", line 949
real Iii, Vdiff, Vdsatii, VgsStep, Ratio, ALPHAII;

// file "Z:/SIdesign/NS1ellip3W//source/bsimcmg_body.include", line 952
real cox_acc;

// file "Z:/SIdesign/NS1ellip3W//source/bsimcmg_body.include", line 953
real qg_acc, qb_acc;

// file "Z:/SIdesign/NS1ellip3W//source/bsimcmg_body.include", line 954
real vge;

// file "Z:/SIdesign/NS1ellip3W//source/bsimcmg_body.include", line 957
real qgs_ov, qgd_ov, qgs_fr, qgd_fr, qds_fr;

// file "Z:/SIdesign/NS1ellip3W//source/bsimcmg_body.include", line 958
real qgs_parasitic, qgd_parasitic, Qes, Qed, Qeg;

// file "Z:/SIdesign/NS1ellip3W//source/bsimcmg_body.include", line 959
real vgs_overlap, vgd_overlap, vge_overlap;

// file "Z:/SIdesign/NS1ellip3W//source/bsimcmg_body.include", line 960
real cgsp, cgdp, csbox, cdbox, cgbox, vfbsdcv;

// file "Z:/SIdesign/NS1ellip3W//source/bsimcmg_body.include", line 963
real Ies, Ied, ves_jct, ved_jct, vec;

// file "Z:/SIdesign/NS1ellip3W//source/bsimcmg_body.include", line 964
real Czbs, Czbssw, Czbsswg, Czbd, Czbdsw, Czbdswg;

// file "Z:/SIdesign/NS1ellip3W//source/bsimcmg_body.include", line 965
real pb2, arg, sarg, Qec;

// file "Z:/SIdesign/NS1ellip3W//source/bsimcmg_body.include", line 966
real Qesj, Qesj1, Qesj2, Qesj3, Qedj, Qedj1, Qedj2, Qedj3;

// file "Z:/SIdesign/NS1ellip3W//source/bsimcmg_body.include", line 967
real Isbs, Isbd, Nvtms, Nvtmd;

// file "Z:/SIdesign/NS1ellip3W//source/bsimcmg_body.include", line 968
real SslpRev, IVjsmRev, VjsmRev, SslpFwd, IVjsmFwd, VjsmFwd, XExpBVS;

// file "Z:/SIdesign/NS1ellip3W//source/bsimcmg_body.include", line 969
real DslpRev, IVjdmRev, VjdmRev, DslpFwd, IVjdmFwd, VjdmFwd, XExpBVD;

// file "Z:/SIdesign/NS1ellip3W//source/bsimcmg_body.include", line 970
real igentemp, idsgen, LINTIGEN_i;

// file "Z:/SIdesign/NS1ellip3W//source/bsimcmg_body.include", line 985
real LINTNOI_i;

// file "Z:/SIdesign/NS1ellip3W//source/bsimcmg_body.include", line 986
real litl, Esatnoi, Leffnoi, Leffnoisq, DelClm;

// file "Z:/SIdesign/NS1ellip3W//source/bsimcmg_body.include", line 987
real N0, Nl, Nstar, Ssi, Swi, FNPowerAt1Hz;

// file "Z:/SIdesign/NS1ellip3W//source/bsimcmg_body.include", line 990
real NTNOI_i, qinv;

// file "Z:/SIdesign/NS1ellip3W//source/bsimcmg_body.include", line 991
real Gtnoi, sid;

// file "Z:/SIdesign/NS1ellip3W//source/bsimcmg_body.include", line 992
real gspr, gdpr;

// file "Z:/SIdesign/NS1ellip3W//source/bsimcmg_body.include", line 996
real Abulk, etaa, gamma, delta, epsilon, gche;

// file "Z:/SIdesign/NS1ellip3W//source/bsimcmg_body.include", line 997
real npart_beta, npart_theta, ctnoi, npart_c;

// file "Z:/SIdesign/NS1ellip3W//source/bsimcmg_body.include", line 998
real noiGd0, GammaGd0, C0, sf;

// file "Z:/SIdesign/NS1ellip3W//source/bsimcmg_body.include", line 1003
real gth, cth;

// file "Z:/SIdesign/NS1ellip3W//source/bsimcmg_body.include", line 1007
real Inv_L, Inv_NFIN, Inv_LNFIN;

// file "Z:/SIdesign/NS1ellip3W//source/bsimcmg_body.include", line 1008
real NBODY_i, PHIG_i, CFD_i, CFS_i, COVS_i, COVD_i, CGSO_i, CGDO_i;

// file "Z:/SIdesign/NS1ellip3W//source/bsimcmg_body.include", line 1009
real CGSL_i, CGDL_i, CGBL_i, CKAPPAS_i, CKAPPAD_i, CKAPPAB_i;

// file "Z:/SIdesign/NS1ellip3W//source/bsimcmg_body.include", line 1010
real QMFACTOR_i, QMTCENCV_i, QMTCENCVA_i, KSATIV_i, KSATIVR_i, KSATIV_a;

// file "Z:/SIdesign/NS1ellip3W//source/bsimcmg_body.include", line 1011
real CDSC_i, CDSCD_i, CDSCD_a, CDSCDR_i, CIT_i, DVT0_i, CITR_i, CIT_a;

// file "Z:/SIdesign/NS1ellip3W//source/bsimcmg_body.include", line 1012
real DVT1_i, DVT1SS_i, PHIN_i, ETA0_i, ETA0_a, ETA0R_i, DSUB_i, VSAT_i, VSATR_i, VSATR_t;

// file "Z:/SIdesign/NS1ellip3W//source/bsimcmg_body.include", line 1013
real DVTP0_i, DVTP1_i;

// file "Z:/SIdesign/NS1ellip3W//source/bsimcmg_body.include", line 1014
real K0_i, K01_i, K0SI_i, K0SI1_i, K2SI_i, K2SI1_i, PHIBE_i, K1_i, K11_i, K2SAT_i, K2SAT1_i;

// file "Z:/SIdesign/NS1ellip3W//source/bsimcmg_body.include", line 1015
real DELTAVSAT_i, PSAT_i, DELTAVSATCV_i, PSATCV_i, VSAT1_i, VSAT1R_i, PTWG_i, PTWGR_i, VSATCV_i;

// file "Z:/SIdesign/NS1ellip3W//source/bsimcmg_body.include", line 1016
real UP_i, U0_i, U0R_i, ETAMOB_i, NGATE_i, RDSW_i, UPR_i;

// file "Z:/SIdesign/NS1ellip3W//source/bsimcmg_body.include", line 1017
real PRWGS_i, PRWGD_i, WR_i, PDIBL1_i, PDIBL1R_i, PDIBL2_i, PDIBL2R_i, PDIBL2_a;

// file "Z:/SIdesign/NS1ellip3W//source/bsimcmg_body.include", line 1018
real DROUT_i, PVAG_i;

// file "Z:/SIdesign/NS1ellip3W//source/bsimcmg_body.include", line 1019
real AIGBINV_i, AIGBINV1_i, BIGBINV_i, CIGBINV_i, EIGBINV_i, NIGBINV_i;

// file "Z:/SIdesign/NS1ellip3W//source/bsimcmg_body.include", line 1020
real AIGBACC_i, AIGBACC1_i, BIGBACC_i, CIGBACC_i, NIGBACC_i;

// file "Z:/SIdesign/NS1ellip3W//source/bsimcmg_body.include", line 1021
real AIGC_i, AIGC1_i, BIGC_i, CIGC_i, PIGCD_i;

// file "Z:/SIdesign/NS1ellip3W//source/bsimcmg_body.include", line 1022
real AIGS_i, AIGS1_i, BIGS_i, CIGS_i, NTOX_i, POXEDGE_i;

// file "Z:/SIdesign/NS1ellip3W//source/bsimcmg_body.include", line 1023
real AIGD_i, AIGD1_i, BIGD_i, CIGD_i;

// file "Z:/SIdesign/NS1ellip3W//source/bsimcmg_body.include", line 1024
real AGIDL_i, BGIDL_i, CGIDL_i, EGIDL_i, PGIDL_i;

// file "Z:/SIdesign/NS1ellip3W//source/bsimcmg_body.include", line 1025
real AGISL_i, BGISL_i, CGISL_i, EGISL_i, PGISL_i;

// file "Z:/SIdesign/NS1ellip3W//source/bsimcmg_body.include", line 1026
real ALPHA0_i, ALPHA1_i, ALPHAII0_i, ALPHAII1_i, BETA0_i;

// file "Z:/SIdesign/NS1ellip3W//source/bsimcmg_body.include", line 1027
real BETAII0_i, BETAII1_i, BETAII2_i, ESATII_i;

// file "Z:/SIdesign/NS1ellip3W//source/bsimcmg_body.include", line 1028
real LII_i, SII0_i, SII1_i, SII2_i, SIID_i, TII_i;

// file "Z:/SIdesign/NS1ellip3W//source/bsimcmg_body.include", line 1029
real MEXP_i, MEXPR_i;

// file "Z:/SIdesign/NS1ellip3W//source/bsimcmg_body.include", line 1030
real PCLM_i, PCLMG_i, PCLMCV_i, PCLM_a, PCLMR_i;

// file "Z:/SIdesign/NS1ellip3W//source/bsimcmg_body.include", line 1031
real A1_i, A2_i, A11_i, A21_i;

// file "Z:/SIdesign/NS1ellip3W//source/bsimcmg_body.include", line 1032
real K1RSCE_i, LPE0_i, DVTSHIFT_i, DVTSHIFT_a, DVTSHIFTR_i;

// file "Z:/SIdesign/NS1ellip3W//source/bsimcmg_body.include", line 1033
real UA_i, UC_i, EU_i, UD_i, UCS_i, UAR_i, EUR_i, UCR_i, UDR_i, UA_a, UD_a, UC_a, EU_a;

// file "Z:/SIdesign/NS1ellip3W//source/bsimcmg_body.include", line 1034
real UA1_i, UA1R_i, UC1_i, UD1_i, UCSTE_i, UTE_i, UTL_i, EMOBT_i, UC1R_i, UD1R_i, UTER_i, UTLR_i;

// file "Z:/SIdesign/NS1ellip3W//source/bsimcmg_body.include", line 1035
real PTWGT_i;

// file "Z:/SIdesign/NS1ellip3W//source/bsimcmg_body.include", line 1036
real AT_i, ATCV_i, ATR_i;

// file "Z:/SIdesign/NS1ellip3W//source/bsimcmg_body.include", line 1037
real RDW_i, RSW_i;

// file "Z:/SIdesign/NS1ellip3W//source/bsimcmg_body.include", line 1038
real PRT_i, KT1_i, TSS_i, IIT_i, IGT_i, TGIDL_i;

// file "Z:/SIdesign/NS1ellip3W//source/bsimcmg_body.include", line 1039
real NTGEN_i, AIGEN_i, BIGEN_i;

// file "Z:/SIdesign/NS1ellip3W//source/bsimcmg_body.include", line 1040
real K0SISAT_i, K0SISAT1_i;

// file "Z:/SIdesign/NS1ellip3W//source/bsimcmg_body.include", line 1041
real K2SISAT_i, K2SISAT1_i;

// file "Z:/SIdesign/NS1ellip3W//source/bsimcmg_body.include", line 1042
real K2_i, K21_i;

// file "Z:/SIdesign/NS1ellip3W//source/bsimcmg_body.include", line 1045
real Cins, Ach, Weff_UFCM, qdep, rc, vth_fixed_factor_Sub, vth_fixed_factor_SI, qm, Qdep_ov_Cins, qi_acc_for_QM;

// file "Z:/SIdesign/NS1ellip3W//source/bsimcmg_body.include", line 1046
real fieldnormalizationfactor, auxQMfact, QMFACTORCVfinal;

// file "Z:/SIdesign/NS1ellip3W//source/bsimcmg_body.include", line 1047
real psipclamp, sqrtpsip, nq, F0;

// file "Z:/SIdesign/NS1ellip3W//source/bsimcmg_body.include", line 118
real hypmaxE01;

// file "Z:/SIdesign/NS1ellip3W//source/bsimcmg_body.include", line 118
real hypsmoothE02;

// file "Z:/SIdesign/NS1ellip3W//source/bsimcmg_body.include", line 118
real llnE03;

// file "Z:/SIdesign/NS1ellip3W//source/bsimcmg_body.include", line 118
real llnE04;

// file "Z:/SIdesign/NS1ellip3W//source/bsimcmg_body.include", line 118
real llnE05;

// file "Z:/SIdesign/NS1ellip3W//source/bsimcmg_body.include", line 118
real llnE06;

// file "Z:/SIdesign/NS1ellip3W//source/bsimcmg_body.include", line 118
real llnE07;

// file "Z:/SIdesign/NS1ellip3W//source/bsimcmg_body.include", line 118
real llnE08;

// file "Z:/SIdesign/NS1ellip3W//source/bsimcmg_body.include", line 118
real llnE09;

// file "Z:/SIdesign/NS1ellip3W//source/bsimcmg_body.include", line 118
real llnE10;

// file "Z:/SIdesign/NS1ellip3W//source/bsimcmg_body.include", line 118
real llnE11;

// file "Z:/SIdesign/NS1ellip3W//source/bsimcmg_body.include", line 118
real llnE12;

// file "Z:/SIdesign/NS1ellip3W//source/bsimcmg_body.include", line 118
real llnE13;

// file "Z:/SIdesign/NS1ellip3W//source/bsimcmg_body.include", line 118
real lexpE14;

// file "Z:/SIdesign/NS1ellip3W//source/bsimcmg_body.include", line 118
real lexpE15;

// file "Z:/SIdesign/NS1ellip3W//source/bsimcmg_body.include", line 118
real lexpE16;

// file "Z:/SIdesign/NS1ellip3W//source/bsimcmg_body.include", line 118
real lexpE17;

// file "Z:/SIdesign/NS1ellip3W//source/bsimcmg_body.include", line 118
real lexpE18;

// file "Z:/SIdesign/NS1ellip3W//source/bsimcmg_body.include", line 118
real lexpE19;

// file "Z:/SIdesign/NS1ellip3W//source/bsimcmg_body.include", line 118
real lexpE20;

// file "Z:/SIdesign/NS1ellip3W//source/bsimcmg_body.include", line 118
real lexpE21;

// file "Z:/SIdesign/NS1ellip3W//source/bsimcmg_body.include", line 118
real lexpE22;

// file "Z:/SIdesign/NS1ellip3W//source/bsimcmg_body.include", line 118
real lexpE23;

// file "Z:/SIdesign/NS1ellip3W//source/bsimcmg_body.include", line 118
real lexpE24;

// file "Z:/SIdesign/NS1ellip3W//source/bsimcmg_body.include", line 118
real lexpE25;

// file "Z:/SIdesign/NS1ellip3W//source/bsimcmg_body.include", line 118
real lexpE26;

// file "Z:/SIdesign/NS1ellip3W//source/bsimcmg_body.include", line 118
real lexpE27;

// file "Z:/SIdesign/NS1ellip3W//source/bsimcmg_body.include", line 118
real lexpE28;

// file "Z:/SIdesign/NS1ellip3W//source/bsimcmg_body.include", line 118
real lexpE29;

// file "Z:/SIdesign/NS1ellip3W//source/bsimcmg_body.include", line 118
real lexpE30;

// file "Z:/SIdesign/NS1ellip3W//source/bsimcmg_body.include", line 118
real lexpE31;

// file "Z:/SIdesign/NS1ellip3W//source/bsimcmg_body.include", line 118
real lexpE32;

// file "Z:/SIdesign/NS1ellip3W//source/bsimcmg_body.include", line 118
real lexpE33;

// file "Z:/SIdesign/NS1ellip3W//source/bsimcmg_body.include", line 118
real lexpE34;

// file "Z:/SIdesign/NS1ellip3W//source/bsimcmg_body.include", line 118
real lexpE35;

// file "Z:/SIdesign/NS1ellip3W//source/bsimcmg_body.include", line 118
real llnE36;

// file "Z:/SIdesign/NS1ellip3W//source/bsimcmg_body.include", line 118
real lexpE37;

// file "Z:/SIdesign/NS1ellip3W//source/bsimcmg_body.include", line 118
real lexpE38;

// file "Z:/SIdesign/NS1ellip3W//source/bsimcmg_body.include", line 118
real lexpE39;

// file "Z:/SIdesign/NS1ellip3W//source/bsimcmg_body.include", line 118
real llnE40;

// file "Z:/SIdesign/NS1ellip3W//source/bsimcmg_body.include", line 118
real llnE41;

// file "Z:/SIdesign/NS1ellip3W//source/bsimcmg_body.include", line 118
real lexpE42;

// file "Z:/SIdesign/NS1ellip3W//source/bsimcmg_body.include", line 118
real llnE43;

// file "Z:/SIdesign/NS1ellip3W//source/bsimcmg_body.include", line 118
real lexpE44;

// file "Z:/SIdesign/NS1ellip3W//source/bsimcmg_body.include", line 118
real lexpE45;

// file "Z:/SIdesign/NS1ellip3W//source/bsimcmg_body.include", line 118
real hypsmoothE46;

// file "Z:/SIdesign/NS1ellip3W//source/bsimcmg_body.include", line 118
real lexpE47;

// file "Z:/SIdesign/NS1ellip3W//source/bsimcmg_body.include", line 118
real lexpE48;

// file "Z:/SIdesign/NS1ellip3W//source/bsimcmg_body.include", line 118
real lexpE49;

// file "Z:/SIdesign/NS1ellip3W//source/bsimcmg_body.include", line 118
real llnE50;

// file "Z:/SIdesign/NS1ellip3W//source/bsimcmg_body.include", line 118
real TempdepE51;

// file "Z:/SIdesign/NS1ellip3W//source/bsimcmg_body.include", line 118
real TempdepE52;

// file "Z:/SIdesign/NS1ellip3W//source/bsimcmg_body.include", line 118
real hypmaxE53;

// file "Z:/SIdesign/NS1ellip3W//source/bsimcmg_body.include", line 118
real hypmaxE54;

// file "Z:/SIdesign/NS1ellip3W//source/bsimcmg_body.include", line 118
real TempdepE55;

// file "Z:/SIdesign/NS1ellip3W//source/bsimcmg_body.include", line 118
real hypmaxE56;

// file "Z:/SIdesign/NS1ellip3W//source/bsimcmg_body.include", line 118
real hypmaxE57;

// file "Z:/SIdesign/NS1ellip3W//source/bsimcmg_body.include", line 118
real TempdepE58;

// file "Z:/SIdesign/NS1ellip3W//source/bsimcmg_body.include", line 118
real TempdepE59;

// file "Z:/SIdesign/NS1ellip3W//source/bsimcmg_body.include", line 118
real hypsmoothE60;

// file "Z:/SIdesign/NS1ellip3W//source/bsimcmg_body.include", line 118
real TempdepE61;

// file "Z:/SIdesign/NS1ellip3W//source/bsimcmg_body.include", line 118
real TempdepE62;

// file "Z:/SIdesign/NS1ellip3W//source/bsimcmg_body.include", line 118
real TempdepE63;

// file "Z:/SIdesign/NS1ellip3W//source/bsimcmg_body.include", line 118
real TempdepE64;

// file "Z:/SIdesign/NS1ellip3W//source/bsimcmg_body.include", line 118
real TempdepE65;

// file "Z:/SIdesign/NS1ellip3W//source/bsimcmg_body.include", line 118
real TempdepE66;

// file "Z:/SIdesign/NS1ellip3W//source/bsimcmg_body.include", line 118
real TempdepE67;

// file "Z:/SIdesign/NS1ellip3W//source/bsimcmg_body.include", line 118
real TempdepE68;

// file "Z:/SIdesign/NS1ellip3W//source/bsimcmg_body.include", line 118
real TempdepE69;

// file "Z:/SIdesign/NS1ellip3W//source/bsimcmg_body.include", line 118
real hypsmoothE70;

// file "Z:/SIdesign/NS1ellip3W//source/bsimcmg_body.include", line 118
real hypsmoothE71;

// file "Z:/SIdesign/NS1ellip3W//source/bsimcmg_body.include", line 118
real TempdepE72;

// file "Z:/SIdesign/NS1ellip3W//source/bsimcmg_body.include", line 118
real TempdepE73;

// file "Z:/SIdesign/NS1ellip3W//source/bsimcmg_body.include", line 118
real hypsmoothE74;

// file "Z:/SIdesign/NS1ellip3W//source/bsimcmg_body.include", line 118
real hypmaxE75;

// file "Z:/SIdesign/NS1ellip3W//source/bsimcmg_body.include", line 118
real hypmaxE76;

// file "Z:/SIdesign/NS1ellip3W//source/bsimcmg_body.include", line 118
real hypmaxE77;

// file "Z:/SIdesign/NS1ellip3W//source/bsimcmg_body.include", line 118
real hypmaxE78;

// file "Z:/SIdesign/NS1ellip3W//source/bsimcmg_body.include", line 118
real hypmaxE79;

// file "Z:/SIdesign/NS1ellip3W//source/bsimcmg_body.include", line 118
real hypmaxE80;

// file "Z:/SIdesign/NS1ellip3W//source/bsimcmg_body.include", line 118
real hypmaxE81;

// file "Z:/SIdesign/NS1ellip3W//source/bsimcmg_body.include", line 118
real hypmaxE82;

// file "Z:/SIdesign/NS1ellip3W//source/bsimcmg_body.include", line 118
real hypmaxE83;

// file "Z:/SIdesign/NS1ellip3W//source/bsimcmg_body.include", line 118
real hypsmoothE84;

// file "Z:/SIdesign/NS1ellip3W//source/bsimcmg_body.include", line 118
real hypsmoothE85;

// file "Z:/SIdesign/NS1ellip3W//source/bsimcmg_body.include", line 118
real hypmaxE86;

// file "Z:/SIdesign/NS1ellip3W//source/bsimcmg_body.include", line 118
real hypmaxE87;

// file "Z:/SIdesign/NS1ellip3W//source/bsimcmg_body.include", line 118
real hypmaxE88;

// file "Z:/SIdesign/NS1ellip3W//source/bsimcmg_body.include", line 118
real hypmaxE89;

// file "Z:/SIdesign/NS1ellip3W//source/bsimcmg_body.include", line 118
real llnE90;

// file "Z:/SIdesign/NS1ellip3W//source/bsimcmg_body.include", line 118
real lexpE91;

// file "Z:/SIdesign/NS1ellip3W//source/bsimcmg_body.include", line 118
real TempdepE92;

// file "Z:/SIdesign/NS1ellip3W//source/bsimcmg_body.include", line 118
real TempdepE93;

// file "Z:/SIdesign/NS1ellip3W//source/bsimcmg_body.include", line 118
real TempdepE94;

// file "Z:/SIdesign/NS1ellip3W//source/bsimcmg_body.include", line 118
real TempdepE95;

// file "Z:/SIdesign/NS1ellip3W//source/bsimcmg_body.include", line 118
real TempdepE96;

// file "Z:/SIdesign/NS1ellip3W//source/bsimcmg_body.include", line 118
real TempdepE97;

// file "Z:/SIdesign/NS1ellip3W//source/bsimcmg_body.include", line 118
real hypsmoothE98;

// file "Z:/SIdesign/NS1ellip3W//source/bsimcmg_body.include", line 118
real hypsmoothE99;

// file "Z:/SIdesign/NS1ellip3W//source/bsimcmg_body.include", line 118
real hypsmoothE100;

// file "Z:/SIdesign/NS1ellip3W//source/bsimcmg_body.include", line 118
real hypsmoothE101;

// file "Z:/SIdesign/NS1ellip3W//source/bsimcmg_body.include", line 118
real hypsmoothE102;

// file "Z:/SIdesign/NS1ellip3W//source/bsimcmg_body.include", line 118
real hypsmoothE103;

// file "Z:/SIdesign/NS1ellip3W//source/bsimcmg_body.include", line 118
real llnE104;

// file "Z:/SIdesign/NS1ellip3W//source/bsimcmg_body.include", line 118
real lexpE105;

// file "Z:/SIdesign/NS1ellip3W//source/bsimcmg_body.include", line 118
real lexpE106;

// file "Z:/SIdesign/NS1ellip3W//source/bsimcmg_body.include", line 118
real lexpE107;

// file "Z:/SIdesign/NS1ellip3W//source/bsimcmg_body.include", line 118
real lexpE108;

// file "Z:/SIdesign/NS1ellip3W//source/bsimcmg_body.include", line 118
real lexpE109;

// file "Z:/SIdesign/NS1ellip3W//source/bsimcmg_body.include", line 118
real lexpE110;

// file "Z:/SIdesign/NS1ellip3W//source/bsimcmg_body.include", line 118
real lexpE111;

// file "Z:/SIdesign/NS1ellip3W//source/bsimcmg_body.include", line 118
real lexpE112;

// file "Z:/SIdesign/NS1ellip3W//source/bsimcmg_body.include", line 118
real hypsmoothE113;

// file "Z:/SIdesign/NS1ellip3W//source/bsimcmg_body.include", line 118
real hypsmoothE114;

// file "Z:/SIdesign/NS1ellip3W//source/bsimcmg_body.include", line 118
real hypsmoothE115;

// file "Z:/SIdesign/NS1ellip3W//source/bsimcmg_body.include", line 118
real hypsmoothE116;

// file "Z:/SIdesign/NS1ellip3W//source/bsimcmg_body.include", line 118
real hypsmoothE117;

// file "Z:/SIdesign/NS1ellip3W//source/bsimcmg_body.include", line 118
real hypsmoothE118;

// file "Z:/SIdesign/NS1ellip3W//source/bsimcmg_body.include", line 118
real llnE119;

// file "Z:/SIdesign/NS1ellip3W//source/bsimcmg_body.include", line 118
real hypsmoothE120;

// file "Z:/SIdesign/NS1ellip3W//source/bsimcmg_body.include", line 118
real llnE121;

// file "Z:/SIdesign/NS1ellip3W//source/bsimcmg_body.include", line 118
real hypsmoothE122;

// file "Z:/SIdesign/NS1ellip3W//source/bsimcmg_body.include", line 118
real llnE123;

// file "Z:/SIdesign/NS1ellip3W//source/bsimcmg_body.include", line 118
real hypsmoothE124;

// file "Z:/SIdesign/NS1ellip3W//source/bsimcmg_body.include", line 118
real llnE125;

// file "Z:/SIdesign/NS1ellip3W//source/bsimcmg_body.include", line 118
real llnE126;

// file "Z:/SIdesign/NS1ellip3W//source/bsimcmg_body.include", line 118
real llnE127;

// file "Z:/SIdesign/NS1ellip3W//source/bsimcmg_body.include", line 118
real llnE128;

// file "Z:/SIdesign/NS1ellip3W//source/bsimcmg_body.include", line 118
real lexpE129;

// file "Z:/SIdesign/NS1ellip3W//source/bsimcmg_body.include", line 118
real llnE130;

// file "Z:/SIdesign/NS1ellip3W//source/bsimcmg_body.include", line 118
real lexpE131;

// file "Z:/SIdesign/NS1ellip3W//source/bsimcmg_body.include", line 118
real hypsmoothE132;

// file "Z:/SIdesign/NS1ellip3W//source/bsimcmg_body.include", line 118
real llnE133;

// file "Z:/SIdesign/NS1ellip3W//source/bsimcmg_body.include", line 118
real lexpE134;

// file "Z:/SIdesign/NS1ellip3W//source/bsimcmg_body.include", line 118
real lexpE135;

// file "Z:/SIdesign/NS1ellip3W//source/bsimcmg_body.include", line 118
real llnE136;

// file "Z:/SIdesign/NS1ellip3W//source/bsimcmg_body.include", line 118
real lexpE137;

// file "Z:/SIdesign/NS1ellip3W//source/bsimcmg_body.include", line 118
real hypsmoothE138;

// file "Z:/SIdesign/NS1ellip3W//source/bsimcmg_body.include", line 118
real llnE139;

// file "Z:/SIdesign/NS1ellip3W//source/bsimcmg_body.include", line 118
real lexpE140;

// file "Z:/SIdesign/NS1ellip3W//source/bsimcmg_body.include", line 118
real lexpE141;

// file "Z:/SIdesign/NS1ellip3W//source/bsimcmg_body.include", line 118
real llnE142;

// file "Z:/SIdesign/NS1ellip3W//source/bsimcmg_body.include", line 118
real hypsmoothE143;

// file "Z:/SIdesign/NS1ellip3W//source/bsimcmg_body.include", line 118
real hypsmoothE144;

// file "Z:/SIdesign/NS1ellip3W//source/bsimcmg_body.include", line 118
real hypsmoothE145;

// file "Z:/SIdesign/NS1ellip3W//source/bsimcmg_body.include", line 118
real hypsmoothE146;

// file "Z:/SIdesign/NS1ellip3W//source/bsimcmg_body.include", line 118
real lexpE147;

// file "Z:/SIdesign/NS1ellip3W//source/bsimcmg_body.include", line 118
real llnE148;

// file "Z:/SIdesign/NS1ellip3W//source/bsimcmg_body.include", line 118
real llnE149;

// file "Z:/SIdesign/NS1ellip3W//source/bsimcmg_body.include", line 118
real lexpE150;

// file "Z:/SIdesign/NS1ellip3W//source/bsimcmg_body.include", line 118
real llnE151;

// file "Z:/SIdesign/NS1ellip3W//source/bsimcmg_body.include", line 118
real lexpE152;

// file "Z:/SIdesign/NS1ellip3W//source/bsimcmg_body.include", line 118
real llnE153;

// file "Z:/SIdesign/NS1ellip3W//source/bsimcmg_body.include", line 118
real lexpE154;

// file "Z:/SIdesign/NS1ellip3W//source/bsimcmg_body.include", line 118
real lexpE155;

// file "Z:/SIdesign/NS1ellip3W//source/bsimcmg_body.include", line 118
real hypsmoothE156;

// file "Z:/SIdesign/NS1ellip3W//source/bsimcmg_body.include", line 118
real lexpE157;

// file "Z:/SIdesign/NS1ellip3W//source/bsimcmg_body.include", line 118
real llnE158;

// file "Z:/SIdesign/NS1ellip3W//source/bsimcmg_body.include", line 118
real lexpE159;

// file "Z:/SIdesign/NS1ellip3W//source/bsimcmg_body.include", line 118
real llnE160;

// file "Z:/SIdesign/NS1ellip3W//source/bsimcmg_body.include", line 118
real lexpE161;

// file "Z:/SIdesign/NS1ellip3W//source/bsimcmg_body.include", line 118
real llnE162;

// file "Z:/SIdesign/NS1ellip3W//source/bsimcmg_body.include", line 118
real lexpE163;

// file "Z:/SIdesign/NS1ellip3W//source/bsimcmg_body.include", line 118
real llnE164;

// file "Z:/SIdesign/NS1ellip3W//source/bsimcmg_body.include", line 118
real llnE165;

// file "Z:/SIdesign/NS1ellip3W//source/bsimcmg_body.include", line 118
real lexpE166;

// file "Z:/SIdesign/NS1ellip3W//source/bsimcmg_body.include", line 118
real llnE167;

// file "Z:/SIdesign/NS1ellip3W//source/bsimcmg_body.include", line 118
real lexpE168;

// file "Z:/SIdesign/NS1ellip3W//source/bsimcmg_body.include", line 118
real lexpE169;

// file "Z:/SIdesign/NS1ellip3W//source/bsimcmg_body.include", line 118
real hypsmoothE170;

// file "Z:/SIdesign/NS1ellip3W//source/bsimcmg_body.include", line 118
real hypsmoothE171;

// file "Z:/SIdesign/NS1ellip3W//source/bsimcmg_body.include", line 118
real lexpE172;

// file "Z:/SIdesign/NS1ellip3W//source/bsimcmg_body.include", line 118
real hypmaxE173;

// file "Z:/SIdesign/NS1ellip3W//source/bsimcmg_body.include", line 118
real lexpE174;

// file "Z:/SIdesign/NS1ellip3W//source/bsimcmg_body.include", line 118
real llnE175;

// file "Z:/SIdesign/NS1ellip3W//source/bsimcmg_body.include", line 118
real lexpE176;

// file "Z:/SIdesign/NS1ellip3W//source/bsimcmg_body.include", line 118
real lexpE177;

// file "Z:/SIdesign/NS1ellip3W//source/bsimcmg_body.include", line 118
real llnE178;

// file "Z:/SIdesign/NS1ellip3W//source/bsimcmg_body.include", line 118
real lexpE179;

// file "Z:/SIdesign/NS1ellip3W//source/bsimcmg_body.include", line 118
real lexpE180;

// file "Z:/SIdesign/NS1ellip3W//source/bsimcmg_body.include", line 118
real lexpE181;

// file "Z:/SIdesign/NS1ellip3W//source/bsimcmg_body.include", line 118
real hypsmoothE182;

// file "Z:/SIdesign/NS1ellip3W//source/bsimcmg_body.include", line 118
real lexpE183;

// file "Z:/SIdesign/NS1ellip3W//source/bsimcmg_body.include", line 118
real hypsmoothE184;

// file "Z:/SIdesign/NS1ellip3W//source/bsimcmg_body.include", line 118
real lexpE185;

// file "Z:/SIdesign/NS1ellip3W//source/bsimcmg_body.include", line 118
real hypsmoothE186;

// file "Z:/SIdesign/NS1ellip3W//source/bsimcmg_body.include", line 118
real llnE187;

// file "Z:/SIdesign/NS1ellip3W//source/bsimcmg_body.include", line 118
real lexpE188;

// file "Z:/SIdesign/NS1ellip3W//source/bsimcmg_body.include", line 118
real hypsmoothE189;

// file "Z:/SIdesign/NS1ellip3W//source/bsimcmg_body.include", line 118
real lexpE190;

// file "Z:/SIdesign/NS1ellip3W//source/bsimcmg_body.include", line 118
real lexpE191;

// file "Z:/SIdesign/NS1ellip3W//source/bsimcmg_body.include", line 118
real hypsmoothE192;

// file "Z:/SIdesign/NS1ellip3W//source/bsimcmg_body.include", line 118
real llnE193;

// file "Z:/SIdesign/NS1ellip3W//source/bsimcmg_body.include", line 118
real lexpE194;

// file "Z:/SIdesign/NS1ellip3W//source/bsimcmg_body.include", line 118
real hypsmoothE195;

// file "Z:/SIdesign/NS1ellip3W//source/bsimcmg_body.include", line 118
real lexpE196;

// file "Z:/SIdesign/NS1ellip3W//source/bsimcmg_body.include", line 118
real lexpE197;

// file "Z:/SIdesign/NS1ellip3W//source/bsimcmg_body.include", line 118
real lexpE198;

// file "Z:/SIdesign/NS1ellip3W//source/bsimcmg_body.include", line 118
real lexpE199;

// file "Z:/SIdesign/NS1ellip3W//source/bsimcmg_body.include", line 118
real lexpE200;

// file "Z:/SIdesign/NS1ellip3W//source/bsimcmg_body.include", line 118
real lexpE201;

// file "Z:/SIdesign/NS1ellip3W//source/bsimcmg_body.include", line 118
real lexpE202;

// file "Z:/SIdesign/NS1ellip3W//source/bsimcmg_body.include", line 118
real lexpE203;

// file "Z:/SIdesign/NS1ellip3W//source/bsimcmg_body.include", line 118
real lexpE204;

// file "Z:/SIdesign/NS1ellip3W//source/bsimcmg_body.include", line 118
real lexpE205;

// file "Z:/SIdesign/NS1ellip3W//source/bsimcmg_body.include", line 118
real lexpE206;

// file "Z:/SIdesign/NS1ellip3W//source/bsimcmg_body.include", line 118
real lexpE207;

// file "Z:/SIdesign/NS1ellip3W//source/bsimcmg_body.include", line 118
real lexpE208;

// file "Z:/SIdesign/NS1ellip3W//source/bsimcmg_body.include", line 118
real lexpE209;

// file "Z:/SIdesign/NS1ellip3W//source/bsimcmg_body.include", line 118
real lexpE210;

// file "Z:/SIdesign/NS1ellip3W//source/bsimcmg_body.include", line 118
real lexpE211;

// file "Z:/SIdesign/NS1ellip3W//source/bsimcmg_body.include", line 118
real lexpE212;

// file "Z:/SIdesign/NS1ellip3W//source/bsimcmg_body.include", line 118
real lexpE213;

// file "Z:/SIdesign/NS1ellip3W//source/bsimcmg_body.include", line 118
real lexpE214;

// file "Z:/SIdesign/NS1ellip3W//source/bsimcmg_body.include", line 118
real lexpE215;

// file "Z:/SIdesign/NS1ellip3W//source/bsimcmg_body.include", line 118
real llnE216;

// file "Z:/SIdesign/NS1ellip3W//source/bsimcmg_body.include", line 118
real lexpE217;

// file "Z:/SIdesign/NS1ellip3W//source/bsimcmg_body.include", line 118
real llnE218;

// file "Z:/SIdesign/NS1ellip3W//source/bsimcmg_body.include", line 118
real lexpE219;

// file "Z:/SIdesign/NS1ellip3W//source/bsimcmg_body.include", line 118
real llnE220;

// file "Z:/SIdesign/NS1ellip3W//source/bsimcmg_body.include", line 118
real lexpE221;

// file "Z:/SIdesign/NS1ellip3W//source/bsimcmg_body.include", line 118
real llnE222;

// file "Z:/SIdesign/NS1ellip3W//source/bsimcmg_body.include", line 118
real lexpE223;

// file "Z:/SIdesign/NS1ellip3W//source/bsimcmg_body.include", line 118
real llnE224;

// file "Z:/SIdesign/NS1ellip3W//source/bsimcmg_body.include", line 118
real lexpE225;

// file "Z:/SIdesign/NS1ellip3W//source/bsimcmg_body.include", line 118
real llnE226;

// file "Z:/SIdesign/NS1ellip3W//source/bsimcmg_body.include", line 118
real lexpE227;

// file "Z:/SIdesign/NS1ellip3W//source/bsimcmg_body.include", line 118
real lexpE228;

// file "Z:/SIdesign/NS1ellip3W//source/bsimcmg_body.include", line 118
real llnE229;

// file "Z:/SIdesign/NS1ellip3W//source/bsimcmg_body.include", line 118
real lexpE230;

// file "Z:/SIdesign/NS1ellip3W//source/bsimcmg_body.include", line 118
real llnE231;

// file "Z:/SIdesign/NS1ellip3W//source/bsimcmg_body.include", line 118
real lexpE232;

// file "Z:/SIdesign/NS1ellip3W//source/bsimcmg_body.include", line 118
real llnE233;

// file "Z:/SIdesign/NS1ellip3W//source/bsimcmg_body.include", line 118
real lexpE234;

// file "Z:/SIdesign/NS1ellip3W//source/bsimcmg_body.include", line 118
real llnE235;

// file "Z:/SIdesign/NS1ellip3W//source/bsimcmg_body.include", line 118
real lexpE236;

// file "Z:/SIdesign/NS1ellip3W//source/bsimcmg_body.include", line 118
real llnE237;

// file "Z:/SIdesign/NS1ellip3W//source/bsimcmg_body.include", line 118
real lexpE238;

// file "Z:/SIdesign/NS1ellip3W//source/bsimcmg_body.include", line 118
real llnE239;

// file "Z:/SIdesign/NS1ellip3W//source/bsimcmg_body.include", line 118
real lexpE240;

// file "Z:/SIdesign/NS1ellip3W//source/bsimcmg_body.include", line 118
real lexpE241;

// file "Z:/SIdesign/NS1ellip3W//source/bsimcmg_body.include", line 118
real llnE242;

// file "Z:/SIdesign/NS1ellip3W//source/bsimcmg_body.include", line 118
real lexpE243;

// file "Z:/SIdesign/NS1ellip3W//source/bsimcmg_body.include", line 118
real llnE244;

// file "Z:/SIdesign/NS1ellip3W//source/bsimcmg_body.include", line 118
real lexpE245;

// file "Z:/SIdesign/NS1ellip3W//source/bsimcmg_body.include", line 118
real llnE246;

// file "Z:/SIdesign/NS1ellip3W//source/bsimcmg_body.include", line 118
real lexpE247;

// file "Z:/SIdesign/NS1ellip3W//source/bsimcmg_body.include", line 118
real llnE248;

// file "Z:/SIdesign/NS1ellip3W//source/bsimcmg_body.include", line 118
real lexpE249;

// file "Z:/SIdesign/NS1ellip3W//source/bsimcmg_body.include", line 118
real llnE250;

// file "Z:/SIdesign/NS1ellip3W//source/bsimcmg_body.include", line 118
real lexpE251;

// file "Z:/SIdesign/NS1ellip3W//source/bsimcmg_body.include", line 118
real llnE252;

// file "Z:/SIdesign/NS1ellip3W//source/bsimcmg_body.include", line 118
real lexpE253;

// file "Z:/SIdesign/NS1ellip3W//source/bsimcmg_body.include", line 118
real lexpE254;

// file "Z:/SIdesign/NS1ellip3W//source/bsimcmg_body.include", line 118
real llnE255;

// file "Z:/SIdesign/NS1ellip3W//source/bsimcmg_body.include", line 118
real lexpE256;

// file "Z:/SIdesign/NS1ellip3W//source/bsimcmg_body.include", line 118
real llnE257;

// file "Z:/SIdesign/NS1ellip3W//source/bsimcmg_body.include", line 118
real lexpE258;

// file "Z:/SIdesign/NS1ellip3W//source/bsimcmg_body.include", line 118
real llnE259;

// file "Z:/SIdesign/NS1ellip3W//source/bsimcmg_body.include", line 118
real lexpE260;

// file "Z:/SIdesign/NS1ellip3W//source/bsimcmg_body.include", line 118
real llnE261;

// file "Z:/SIdesign/NS1ellip3W//source/bsimcmg_body.include", line 118
real lexpE262;

// file "Z:/SIdesign/NS1ellip3W//source/bsimcmg_body.include", line 118
real llnE263;

// file "Z:/SIdesign/NS1ellip3W//source/bsimcmg_body.include", line 118
real lexpE264;

// file "Z:/SIdesign/NS1ellip3W//source/bsimcmg_body.include", line 118
real llnE265;

// file "Z:/SIdesign/NS1ellip3W//source/bsimcmg_body.include", line 118
real lexpE266;

// file "Z:/SIdesign/NS1ellip3W//source/bsimcmg_body.include", line 118
real lexpE267;

// file "Z:/SIdesign/NS1ellip3W//source/bsimcmg_body.include", line 118
real llnE268;

// file "Z:/SIdesign/NS1ellip3W//source/bsimcmg_body.include", line 118
real lexpE269;

// file "Z:/SIdesign/NS1ellip3W//source/bsimcmg_body.include", line 118
real llnE270;

// file "Z:/SIdesign/NS1ellip3W//source/bsimcmg_body.include", line 118
real lexpE271;

// file "Z:/SIdesign/NS1ellip3W//source/bsimcmg_body.include", line 118
real llnE272;

// file "Z:/SIdesign/NS1ellip3W//source/bsimcmg_body.include", line 118
real lexpE273;

// file "Z:/SIdesign/NS1ellip3W//source/bsimcmg_body.include", line 118
real llnE274;

// file "Z:/SIdesign/NS1ellip3W//source/bsimcmg_body.include", line 118
real lexpE275;

// file "Z:/SIdesign/NS1ellip3W//source/bsimcmg_body.include", line 118
real llnE276;

// file "Z:/SIdesign/NS1ellip3W//source/bsimcmg_body.include", line 118
real lexpE277;

// file "Z:/SIdesign/NS1ellip3W//source/bsimcmg_body.include", line 118
real llnE278;

// file "Z:/SIdesign/NS1ellip3W//source/bsimcmg_body.include", line 118
real lexpE279;

// file "Z:/SIdesign/NS1ellip3W//source/bsimcmg_body.include", line 118
real lexpE280;

// file "Z:/SIdesign/NS1ellip3W//source/bsimcmg_body.include", line 118
real llnE281;

// file "Z:/SIdesign/NS1ellip3W//source/bsimcmg_body.include", line 118
real lexpE282;

// file "Z:/SIdesign/NS1ellip3W//source/bsimcmg_body.include", line 118
real llnE283;

// file "Z:/SIdesign/NS1ellip3W//source/bsimcmg_body.include", line 118
real lexpE284;

// file "Z:/SIdesign/NS1ellip3W//source/bsimcmg_body.include", line 118
real llnE285;

// file "Z:/SIdesign/NS1ellip3W//source/bsimcmg_body.include", line 118
real lexpE286;

// file "Z:/SIdesign/NS1ellip3W//source/bsimcmg_body.include", line 118
real llnE287;

// file "Z:/SIdesign/NS1ellip3W//source/bsimcmg_body.include", line 118
real lexpE288;

// file "Z:/SIdesign/NS1ellip3W//source/bsimcmg_body.include", line 118
real llnE289;

// file "Z:/SIdesign/NS1ellip3W//source/bsimcmg_body.include", line 118
real lexpE290;

// file "Z:/SIdesign/NS1ellip3W//source/bsimcmg_body.include", line 118
real llnE291;

// file "Z:/SIdesign/NS1ellip3W//source/bsimcmg_body.include", line 118
real lexpE292;

// file "Z:/SIdesign/NS1ellip3W//source/bsimcmg_body.include", line 118
real lexpE293;

// file "Z:/SIdesign/NS1ellip3W//source/bsimcmg_body.include", line 118
real llnE294;

// file "Z:/SIdesign/NS1ellip3W//source/bsimcmg_body.include", line 118
real llnE295;

// file "Z:/SIdesign/NS1ellip3W//source/bsimcmg_body.include", line 118
real llnE296;

// file "Z:/SIdesign/NS1ellip3W//source/bsimcmg_body.include", line 118
real llnE297;

// file "Z:/SIdesign/NS1ellip3W//source/bsimcmg_body.include", line 118
real _argR1_1_;

// file "Z:/SIdesign/NS1ellip3W//source/bsimcmg_body.include", line 118
real _argR1_2_;

// file "Z:/SIdesign/NS1ellip3W//source/bsimcmg_body.include", line 118
real _argR1_3_;

// file "Z:/SIdesign/NS1ellip3W//source/bsimcmg_body.include", line 118
real _argR2_1_;

// file "Z:/SIdesign/NS1ellip3W//source/bsimcmg_body.include", line 118
real _argR2_2_;

// file "Z:/SIdesign/NS1ellip3W//source/bsimcmg_body.include", line 118
real _argR3_1_;

// file "Z:/SIdesign/NS1ellip3W//source/bsimcmg_body.include", line 118
real _argR4_1_;

// file "Z:/SIdesign/NS1ellip3W//source/bsimcmg_body.include", line 118
real _argR5_1_;

// file "Z:/SIdesign/NS1ellip3W//source/bsimcmg_body.include", line 118
real _argR6_1_;

// file "Z:/SIdesign/NS1ellip3W//source/bsimcmg_body.include", line 118
real _argR7_1_;

// file "Z:/SIdesign/NS1ellip3W//source/bsimcmg_body.include", line 118
real _argR8_1_;

// file "Z:/SIdesign/NS1ellip3W//source/bsimcmg_body.include", line 118
real _argR9_1_;

// file "Z:/SIdesign/NS1ellip3W//source/bsimcmg_body.include", line 118
real _argR10_1_;

// file "Z:/SIdesign/NS1ellip3W//source/bsimcmg_body.include", line 118
real _argR11_1_;

// file "Z:/SIdesign/NS1ellip3W//source/bsimcmg_body.include", line 118
real _argR12_1_;

// file "Z:/SIdesign/NS1ellip3W//source/bsimcmg_body.include", line 118
real _argR13_1_;

// file "Z:/SIdesign/NS1ellip3W//source/bsimcmg_body.include", line 118
real _argR14_1_;

// file "Z:/SIdesign/NS1ellip3W//source/bsimcmg_body.include", line 118
real _argR15_1_;

// file "Z:/SIdesign/NS1ellip3W//source/bsimcmg_body.include", line 118
real _argR16_1_;

// file "Z:/SIdesign/NS1ellip3W//source/bsimcmg_body.include", line 118
real _argR17_1_;

// file "Z:/SIdesign/NS1ellip3W//source/bsimcmg_body.include", line 118
real _argR18_1_;

// file "Z:/SIdesign/NS1ellip3W//source/bsimcmg_body.include", line 118
real _argR19_1_;

// file "Z:/SIdesign/NS1ellip3W//source/bsimcmg_body.include", line 118
real _argR20_1_;

// file "Z:/SIdesign/NS1ellip3W//source/bsimcmg_body.include", line 118
real _argR21_1_;

// file "Z:/SIdesign/NS1ellip3W//source/bsimcmg_body.include", line 118
real _argR22_1_;

// file "Z:/SIdesign/NS1ellip3W//source/bsimcmg_body.include", line 118
real _argR23_1_;

// file "Z:/SIdesign/NS1ellip3W//source/bsimcmg_body.include", line 118
real _argR24_1_;

// file "Z:/SIdesign/NS1ellip3W//source/bsimcmg_body.include", line 118
real _argR25_1_;

// file "Z:/SIdesign/NS1ellip3W//source/bsimcmg_body.include", line 118
real _argR26_1_;

// file "Z:/SIdesign/NS1ellip3W//source/bsimcmg_body.include", line 118
real _argR27_1_;

// file "Z:/SIdesign/NS1ellip3W//source/bsimcmg_body.include", line 118
real _argR28_1_;

// file "Z:/SIdesign/NS1ellip3W//source/bsimcmg_body.include", line 118
real _argR29_1_;

// file "Z:/SIdesign/NS1ellip3W//source/bsimcmg_body.include", line 118
real _argR30_1_;

// file "Z:/SIdesign/NS1ellip3W//source/bsimcmg_body.include", line 118
real _argR31_1_;

// file "Z:/SIdesign/NS1ellip3W//source/bsimcmg_body.include", line 118
real _argR32_1_;

// file "Z:/SIdesign/NS1ellip3W//source/bsimcmg_body.include", line 118
real _argR33_1_;

// file "Z:/SIdesign/NS1ellip3W//source/bsimcmg_body.include", line 118
real _argR34_1_;

// file "Z:/SIdesign/NS1ellip3W//source/bsimcmg_body.include", line 118
real _argR35_1_;

// file "Z:/SIdesign/NS1ellip3W//source/bsimcmg_body.include", line 118
real _argR36_1_;

// file "Z:/SIdesign/NS1ellip3W//source/bsimcmg_body.include", line 118
real _argR37_1_;

// file "Z:/SIdesign/NS1ellip3W//source/bsimcmg_body.include", line 118
real _argR38_1_;

// file "Z:/SIdesign/NS1ellip3W//source/bsimcmg_body.include", line 118
real _argR39_1_;

// file "Z:/SIdesign/NS1ellip3W//source/bsimcmg_body.include", line 118
real _argR40_1_;

// file "Z:/SIdesign/NS1ellip3W//source/bsimcmg_body.include", line 118
real _argR41_1_;

// file "Z:/SIdesign/NS1ellip3W//source/bsimcmg_body.include", line 118
real _argR42_1_;

// file "Z:/SIdesign/NS1ellip3W//source/bsimcmg_body.include", line 118
real _argR43_1_;

// file "Z:/SIdesign/NS1ellip3W//source/bsimcmg_body.include", line 118
real _argR44_1_;

// file "Z:/SIdesign/NS1ellip3W//source/bsimcmg_body.include", line 118
real _argR45_1_;

// file "Z:/SIdesign/NS1ellip3W//source/bsimcmg_body.include", line 118
real _argR46_1_;

// file "Z:/SIdesign/NS1ellip3W//source/bsimcmg_body.include", line 118
real _argR46_2_;

// file "Z:/SIdesign/NS1ellip3W//source/bsimcmg_body.include", line 118
real _argR47_1_;

// file "Z:/SIdesign/NS1ellip3W//source/bsimcmg_body.include", line 118
real _argR48_1_;

// file "Z:/SIdesign/NS1ellip3W//source/bsimcmg_body.include", line 118
real _argR49_1_;

// file "Z:/SIdesign/NS1ellip3W//source/bsimcmg_body.include", line 118
real _argR50_1_;

// file "Z:/SIdesign/NS1ellip3W//source/bsimcmg_body.include", line 118
real _argR51_1_;

// file "Z:/SIdesign/NS1ellip3W//source/bsimcmg_body.include", line 118
real _argR51_2_;

// file "Z:/SIdesign/NS1ellip3W//source/bsimcmg_body.include", line 118
real _argR51_3_;

// file "Z:/SIdesign/NS1ellip3W//source/bsimcmg_body.include", line 118
real _argR51_4_;

// file "Z:/SIdesign/NS1ellip3W//source/bsimcmg_body.include", line 118
real _argR52_1_;

// file "Z:/SIdesign/NS1ellip3W//source/bsimcmg_body.include", line 118
real _argR52_2_;

// file "Z:/SIdesign/NS1ellip3W//source/bsimcmg_body.include", line 118
real _argR52_3_;

// file "Z:/SIdesign/NS1ellip3W//source/bsimcmg_body.include", line 118
real _argR52_4_;

// file "Z:/SIdesign/NS1ellip3W//source/bsimcmg_body.include", line 118
real _argR53_1_;

// file "Z:/SIdesign/NS1ellip3W//source/bsimcmg_body.include", line 118
real _argR53_2_;

// file "Z:/SIdesign/NS1ellip3W//source/bsimcmg_body.include", line 118
real _argR53_3_;

// file "Z:/SIdesign/NS1ellip3W//source/bsimcmg_body.include", line 118
real _argR54_1_;

// file "Z:/SIdesign/NS1ellip3W//source/bsimcmg_body.include", line 118
real _argR54_2_;

// file "Z:/SIdesign/NS1ellip3W//source/bsimcmg_body.include", line 118
real _argR54_3_;

// file "Z:/SIdesign/NS1ellip3W//source/bsimcmg_body.include", line 118
real _argR55_1_;

// file "Z:/SIdesign/NS1ellip3W//source/bsimcmg_body.include", line 118
real _argR55_2_;

// file "Z:/SIdesign/NS1ellip3W//source/bsimcmg_body.include", line 118
real _argR55_3_;

// file "Z:/SIdesign/NS1ellip3W//source/bsimcmg_body.include", line 118
real _argR55_4_;

// file "Z:/SIdesign/NS1ellip3W//source/bsimcmg_body.include", line 118
real _argR56_1_;

// file "Z:/SIdesign/NS1ellip3W//source/bsimcmg_body.include", line 118
real _argR56_2_;

// file "Z:/SIdesign/NS1ellip3W//source/bsimcmg_body.include", line 118
real _argR56_3_;

// file "Z:/SIdesign/NS1ellip3W//source/bsimcmg_body.include", line 118
real _argR57_1_;

// file "Z:/SIdesign/NS1ellip3W//source/bsimcmg_body.include", line 118
real _argR57_2_;

// file "Z:/SIdesign/NS1ellip3W//source/bsimcmg_body.include", line 118
real _argR57_3_;

// file "Z:/SIdesign/NS1ellip3W//source/bsimcmg_body.include", line 118
real _argR58_1_;

// file "Z:/SIdesign/NS1ellip3W//source/bsimcmg_body.include", line 118
real _argR58_2_;

// file "Z:/SIdesign/NS1ellip3W//source/bsimcmg_body.include", line 118
real _argR58_3_;

// file "Z:/SIdesign/NS1ellip3W//source/bsimcmg_body.include", line 118
real _argR58_4_;

// file "Z:/SIdesign/NS1ellip3W//source/bsimcmg_body.include", line 118
real _argR59_1_;

// file "Z:/SIdesign/NS1ellip3W//source/bsimcmg_body.include", line 118
real _argR59_2_;

// file "Z:/SIdesign/NS1ellip3W//source/bsimcmg_body.include", line 118
real _argR59_3_;

// file "Z:/SIdesign/NS1ellip3W//source/bsimcmg_body.include", line 118
real _argR59_4_;

// file "Z:/SIdesign/NS1ellip3W//source/bsimcmg_body.include", line 118
real _argR60_1_;

// file "Z:/SIdesign/NS1ellip3W//source/bsimcmg_body.include", line 118
real _argR60_2_;

// file "Z:/SIdesign/NS1ellip3W//source/bsimcmg_body.include", line 118
real _argR61_1_;

// file "Z:/SIdesign/NS1ellip3W//source/bsimcmg_body.include", line 118
real _argR61_2_;

// file "Z:/SIdesign/NS1ellip3W//source/bsimcmg_body.include", line 118
real _argR61_3_;

// file "Z:/SIdesign/NS1ellip3W//source/bsimcmg_body.include", line 118
real _argR61_4_;

// file "Z:/SIdesign/NS1ellip3W//source/bsimcmg_body.include", line 118
real _argR62_1_;

// file "Z:/SIdesign/NS1ellip3W//source/bsimcmg_body.include", line 118
real _argR62_2_;

// file "Z:/SIdesign/NS1ellip3W//source/bsimcmg_body.include", line 118
real _argR62_3_;

// file "Z:/SIdesign/NS1ellip3W//source/bsimcmg_body.include", line 118
real _argR62_4_;

// file "Z:/SIdesign/NS1ellip3W//source/bsimcmg_body.include", line 118
real _argR63_1_;

// file "Z:/SIdesign/NS1ellip3W//source/bsimcmg_body.include", line 118
real _argR63_2_;

// file "Z:/SIdesign/NS1ellip3W//source/bsimcmg_body.include", line 118
real _argR63_3_;

// file "Z:/SIdesign/NS1ellip3W//source/bsimcmg_body.include", line 118
real _argR63_4_;

// file "Z:/SIdesign/NS1ellip3W//source/bsimcmg_body.include", line 118
real _argR64_1_;

// file "Z:/SIdesign/NS1ellip3W//source/bsimcmg_body.include", line 118
real _argR64_2_;

// file "Z:/SIdesign/NS1ellip3W//source/bsimcmg_body.include", line 118
real _argR64_3_;

// file "Z:/SIdesign/NS1ellip3W//source/bsimcmg_body.include", line 118
real _argR64_4_;

// file "Z:/SIdesign/NS1ellip3W//source/bsimcmg_body.include", line 118
real _argR65_1_;

// file "Z:/SIdesign/NS1ellip3W//source/bsimcmg_body.include", line 118
real _argR65_2_;

// file "Z:/SIdesign/NS1ellip3W//source/bsimcmg_body.include", line 118
real _argR65_3_;

// file "Z:/SIdesign/NS1ellip3W//source/bsimcmg_body.include", line 118
real _argR65_4_;

// file "Z:/SIdesign/NS1ellip3W//source/bsimcmg_body.include", line 118
real _argR66_1_;

// file "Z:/SIdesign/NS1ellip3W//source/bsimcmg_body.include", line 118
real _argR66_2_;

// file "Z:/SIdesign/NS1ellip3W//source/bsimcmg_body.include", line 118
real _argR66_3_;

// file "Z:/SIdesign/NS1ellip3W//source/bsimcmg_body.include", line 118
real _argR66_4_;

// file "Z:/SIdesign/NS1ellip3W//source/bsimcmg_body.include", line 118
real _argR67_1_;

// file "Z:/SIdesign/NS1ellip3W//source/bsimcmg_body.include", line 118
real _argR67_2_;

// file "Z:/SIdesign/NS1ellip3W//source/bsimcmg_body.include", line 118
real _argR67_3_;

// file "Z:/SIdesign/NS1ellip3W//source/bsimcmg_body.include", line 118
real _argR67_4_;

// file "Z:/SIdesign/NS1ellip3W//source/bsimcmg_body.include", line 118
real _argR68_1_;

// file "Z:/SIdesign/NS1ellip3W//source/bsimcmg_body.include", line 118
real _argR68_2_;

// file "Z:/SIdesign/NS1ellip3W//source/bsimcmg_body.include", line 118
real _argR68_3_;

// file "Z:/SIdesign/NS1ellip3W//source/bsimcmg_body.include", line 118
real _argR68_4_;

// file "Z:/SIdesign/NS1ellip3W//source/bsimcmg_body.include", line 118
real _argR69_1_;

// file "Z:/SIdesign/NS1ellip3W//source/bsimcmg_body.include", line 118
real _argR69_2_;

// file "Z:/SIdesign/NS1ellip3W//source/bsimcmg_body.include", line 118
real _argR69_3_;

// file "Z:/SIdesign/NS1ellip3W//source/bsimcmg_body.include", line 118
real _argR69_4_;

// file "Z:/SIdesign/NS1ellip3W//source/bsimcmg_body.include", line 118
real _argR70_1_;

// file "Z:/SIdesign/NS1ellip3W//source/bsimcmg_body.include", line 118
real _argR70_2_;

// file "Z:/SIdesign/NS1ellip3W//source/bsimcmg_body.include", line 118
real _argR71_1_;

// file "Z:/SIdesign/NS1ellip3W//source/bsimcmg_body.include", line 118
real _argR71_2_;

// file "Z:/SIdesign/NS1ellip3W//source/bsimcmg_body.include", line 118
real _argR72_1_;

// file "Z:/SIdesign/NS1ellip3W//source/bsimcmg_body.include", line 118
real _argR72_2_;

// file "Z:/SIdesign/NS1ellip3W//source/bsimcmg_body.include", line 118
real _argR72_3_;

// file "Z:/SIdesign/NS1ellip3W//source/bsimcmg_body.include", line 118
real _argR72_4_;

// file "Z:/SIdesign/NS1ellip3W//source/bsimcmg_body.include", line 118
real _argR73_1_;

// file "Z:/SIdesign/NS1ellip3W//source/bsimcmg_body.include", line 118
real _argR73_2_;

// file "Z:/SIdesign/NS1ellip3W//source/bsimcmg_body.include", line 118
real _argR73_3_;

// file "Z:/SIdesign/NS1ellip3W//source/bsimcmg_body.include", line 118
real _argR73_4_;

// file "Z:/SIdesign/NS1ellip3W//source/bsimcmg_body.include", line 118
real _argR74_1_;

// file "Z:/SIdesign/NS1ellip3W//source/bsimcmg_body.include", line 118
real _argR74_2_;

// file "Z:/SIdesign/NS1ellip3W//source/bsimcmg_body.include", line 118
real _argR75_1_;

// file "Z:/SIdesign/NS1ellip3W//source/bsimcmg_body.include", line 118
real _argR75_2_;

// file "Z:/SIdesign/NS1ellip3W//source/bsimcmg_body.include", line 118
real _argR75_3_;

// file "Z:/SIdesign/NS1ellip3W//source/bsimcmg_body.include", line 118
real _argR76_1_;

// file "Z:/SIdesign/NS1ellip3W//source/bsimcmg_body.include", line 118
real _argR76_2_;

// file "Z:/SIdesign/NS1ellip3W//source/bsimcmg_body.include", line 118
real _argR76_3_;

// file "Z:/SIdesign/NS1ellip3W//source/bsimcmg_body.include", line 118
real _argR77_1_;

// file "Z:/SIdesign/NS1ellip3W//source/bsimcmg_body.include", line 118
real _argR77_2_;

// file "Z:/SIdesign/NS1ellip3W//source/bsimcmg_body.include", line 118
real _argR77_3_;

// file "Z:/SIdesign/NS1ellip3W//source/bsimcmg_body.include", line 118
real _argR78_1_;

// file "Z:/SIdesign/NS1ellip3W//source/bsimcmg_body.include", line 118
real _argR78_2_;

// file "Z:/SIdesign/NS1ellip3W//source/bsimcmg_body.include", line 118
real _argR78_3_;

// file "Z:/SIdesign/NS1ellip3W//source/bsimcmg_body.include", line 118
real _argR79_1_;

// file "Z:/SIdesign/NS1ellip3W//source/bsimcmg_body.include", line 118
real _argR79_2_;

// file "Z:/SIdesign/NS1ellip3W//source/bsimcmg_body.include", line 118
real _argR79_3_;

// file "Z:/SIdesign/NS1ellip3W//source/bsimcmg_body.include", line 118
real _argR80_1_;

// file "Z:/SIdesign/NS1ellip3W//source/bsimcmg_body.include", line 118
real _argR80_2_;

// file "Z:/SIdesign/NS1ellip3W//source/bsimcmg_body.include", line 118
real _argR80_3_;

// file "Z:/SIdesign/NS1ellip3W//source/bsimcmg_body.include", line 118
real _argR81_1_;

// file "Z:/SIdesign/NS1ellip3W//source/bsimcmg_body.include", line 118
real _argR81_2_;

// file "Z:/SIdesign/NS1ellip3W//source/bsimcmg_body.include", line 118
real _argR81_3_;

// file "Z:/SIdesign/NS1ellip3W//source/bsimcmg_body.include", line 118
real _argR82_1_;

// file "Z:/SIdesign/NS1ellip3W//source/bsimcmg_body.include", line 118
real _argR82_2_;

// file "Z:/SIdesign/NS1ellip3W//source/bsimcmg_body.include", line 118
real _argR82_3_;

// file "Z:/SIdesign/NS1ellip3W//source/bsimcmg_body.include", line 118
real _argR83_1_;

// file "Z:/SIdesign/NS1ellip3W//source/bsimcmg_body.include", line 118
real _argR83_2_;

// file "Z:/SIdesign/NS1ellip3W//source/bsimcmg_body.include", line 118
real _argR83_3_;

// file "Z:/SIdesign/NS1ellip3W//source/bsimcmg_body.include", line 118
real _argR84_1_;

// file "Z:/SIdesign/NS1ellip3W//source/bsimcmg_body.include", line 118
real _argR84_2_;

// file "Z:/SIdesign/NS1ellip3W//source/bsimcmg_body.include", line 118
real _argR85_1_;

// file "Z:/SIdesign/NS1ellip3W//source/bsimcmg_body.include", line 118
real _argR85_2_;

// file "Z:/SIdesign/NS1ellip3W//source/bsimcmg_body.include", line 118
real _argR86_1_;

// file "Z:/SIdesign/NS1ellip3W//source/bsimcmg_body.include", line 118
real _argR86_2_;

// file "Z:/SIdesign/NS1ellip3W//source/bsimcmg_body.include", line 118
real _argR86_3_;

// file "Z:/SIdesign/NS1ellip3W//source/bsimcmg_body.include", line 118
real _argR87_1_;

// file "Z:/SIdesign/NS1ellip3W//source/bsimcmg_body.include", line 118
real _argR87_2_;

// file "Z:/SIdesign/NS1ellip3W//source/bsimcmg_body.include", line 118
real _argR87_3_;

// file "Z:/SIdesign/NS1ellip3W//source/bsimcmg_body.include", line 118
real _argR88_1_;

// file "Z:/SIdesign/NS1ellip3W//source/bsimcmg_body.include", line 118
real _argR88_2_;

// file "Z:/SIdesign/NS1ellip3W//source/bsimcmg_body.include", line 118
real _argR88_3_;

// file "Z:/SIdesign/NS1ellip3W//source/bsimcmg_body.include", line 118
real _argR89_1_;

// file "Z:/SIdesign/NS1ellip3W//source/bsimcmg_body.include", line 118
real _argR89_2_;

// file "Z:/SIdesign/NS1ellip3W//source/bsimcmg_body.include", line 118
real _argR89_3_;

// file "Z:/SIdesign/NS1ellip3W//source/bsimcmg_body.include", line 118
real _argR90_1_;

// file "Z:/SIdesign/NS1ellip3W//source/bsimcmg_body.include", line 118
real _argR91_1_;

// file "Z:/SIdesign/NS1ellip3W//source/bsimcmg_body.include", line 118
real _argR92_1_;

// file "Z:/SIdesign/NS1ellip3W//source/bsimcmg_body.include", line 118
real _argR92_2_;

// file "Z:/SIdesign/NS1ellip3W//source/bsimcmg_body.include", line 118
real _argR92_3_;

// file "Z:/SIdesign/NS1ellip3W//source/bsimcmg_body.include", line 118
real _argR92_4_;

// file "Z:/SIdesign/NS1ellip3W//source/bsimcmg_body.include", line 118
real _argR93_1_;

// file "Z:/SIdesign/NS1ellip3W//source/bsimcmg_body.include", line 118
real _argR93_2_;

// file "Z:/SIdesign/NS1ellip3W//source/bsimcmg_body.include", line 118
real _argR93_3_;

// file "Z:/SIdesign/NS1ellip3W//source/bsimcmg_body.include", line 118
real _argR93_4_;

// file "Z:/SIdesign/NS1ellip3W//source/bsimcmg_body.include", line 118
real _argR94_1_;

// file "Z:/SIdesign/NS1ellip3W//source/bsimcmg_body.include", line 118
real _argR94_2_;

// file "Z:/SIdesign/NS1ellip3W//source/bsimcmg_body.include", line 118
real _argR94_3_;

// file "Z:/SIdesign/NS1ellip3W//source/bsimcmg_body.include", line 118
real _argR94_4_;

// file "Z:/SIdesign/NS1ellip3W//source/bsimcmg_body.include", line 118
real _argR95_1_;

// file "Z:/SIdesign/NS1ellip3W//source/bsimcmg_body.include", line 118
real _argR95_2_;

// file "Z:/SIdesign/NS1ellip3W//source/bsimcmg_body.include", line 118
real _argR95_3_;

// file "Z:/SIdesign/NS1ellip3W//source/bsimcmg_body.include", line 118
real _argR95_4_;

// file "Z:/SIdesign/NS1ellip3W//source/bsimcmg_body.include", line 118
real _argR96_1_;

// file "Z:/SIdesign/NS1ellip3W//source/bsimcmg_body.include", line 118
real _argR96_2_;

// file "Z:/SIdesign/NS1ellip3W//source/bsimcmg_body.include", line 118
real _argR96_3_;

// file "Z:/SIdesign/NS1ellip3W//source/bsimcmg_body.include", line 118
real _argR96_4_;

// file "Z:/SIdesign/NS1ellip3W//source/bsimcmg_body.include", line 118
real _argR97_1_;

// file "Z:/SIdesign/NS1ellip3W//source/bsimcmg_body.include", line 118
real _argR97_2_;

// file "Z:/SIdesign/NS1ellip3W//source/bsimcmg_body.include", line 118
real _argR97_3_;

// file "Z:/SIdesign/NS1ellip3W//source/bsimcmg_body.include", line 118
real _argR97_4_;

// file "Z:/SIdesign/NS1ellip3W//source/bsimcmg_body.include", line 118
real _argR98_1_;

// file "Z:/SIdesign/NS1ellip3W//source/bsimcmg_body.include", line 118
real _argR98_2_;

// file "Z:/SIdesign/NS1ellip3W//source/bsimcmg_body.include", line 118
real _argR99_1_;

// file "Z:/SIdesign/NS1ellip3W//source/bsimcmg_body.include", line 118
real _argR99_2_;

// file "Z:/SIdesign/NS1ellip3W//source/bsimcmg_body.include", line 118
real _argR100_1_;

// file "Z:/SIdesign/NS1ellip3W//source/bsimcmg_body.include", line 118
real _argR100_2_;

// file "Z:/SIdesign/NS1ellip3W//source/bsimcmg_body.include", line 118
real _argR101_1_;

// file "Z:/SIdesign/NS1ellip3W//source/bsimcmg_body.include", line 118
real _argR101_2_;

// file "Z:/SIdesign/NS1ellip3W//source/bsimcmg_body.include", line 118
real _argR102_1_;

// file "Z:/SIdesign/NS1ellip3W//source/bsimcmg_body.include", line 118
real _argR102_2_;

// file "Z:/SIdesign/NS1ellip3W//source/bsimcmg_body.include", line 118
real _argR103_1_;

// file "Z:/SIdesign/NS1ellip3W//source/bsimcmg_body.include", line 118
real _argR103_2_;

// file "Z:/SIdesign/NS1ellip3W//source/bsimcmg_body.include", line 118
real _argR104_1_;

// file "Z:/SIdesign/NS1ellip3W//source/bsimcmg_body.include", line 118
real _argR105_1_;

// file "Z:/SIdesign/NS1ellip3W//source/bsimcmg_body.include", line 118
real _argR106_1_;

// file "Z:/SIdesign/NS1ellip3W//source/bsimcmg_body.include", line 118
real _argR107_1_;

// file "Z:/SIdesign/NS1ellip3W//source/bsimcmg_body.include", line 118
real _argR108_1_;

// file "Z:/SIdesign/NS1ellip3W//source/bsimcmg_body.include", line 118
real _argR109_1_;

// file "Z:/SIdesign/NS1ellip3W//source/bsimcmg_body.include", line 118
real _argR110_1_;

// file "Z:/SIdesign/NS1ellip3W//source/bsimcmg_body.include", line 118
real _argR111_1_;

// file "Z:/SIdesign/NS1ellip3W//source/bsimcmg_body.include", line 118
real _argR112_1_;

// file "Z:/SIdesign/NS1ellip3W//source/bsimcmg_body.include", line 118
real _argR113_1_;

// file "Z:/SIdesign/NS1ellip3W//source/bsimcmg_body.include", line 118
real _argR113_2_;

// file "Z:/SIdesign/NS1ellip3W//source/bsimcmg_body.include", line 118
real _argR114_1_;

// file "Z:/SIdesign/NS1ellip3W//source/bsimcmg_body.include", line 118
real _argR114_2_;

// file "Z:/SIdesign/NS1ellip3W//source/bsimcmg_body.include", line 118
real _argR115_1_;

// file "Z:/SIdesign/NS1ellip3W//source/bsimcmg_body.include", line 118
real _argR115_2_;

// file "Z:/SIdesign/NS1ellip3W//source/bsimcmg_body.include", line 118
real _argR116_1_;

// file "Z:/SIdesign/NS1ellip3W//source/bsimcmg_body.include", line 118
real _argR116_2_;

// file "Z:/SIdesign/NS1ellip3W//source/bsimcmg_body.include", line 118
real _argR117_1_;

// file "Z:/SIdesign/NS1ellip3W//source/bsimcmg_body.include", line 118
real _argR117_2_;

// file "Z:/SIdesign/NS1ellip3W//source/bsimcmg_body.include", line 118
real _argR118_1_;

// file "Z:/SIdesign/NS1ellip3W//source/bsimcmg_body.include", line 118
real _argR118_2_;

// file "Z:/SIdesign/NS1ellip3W//source/bsimcmg_body.include", line 118
real _argR119_1_;

// file "Z:/SIdesign/NS1ellip3W//source/bsimcmg_body.include", line 118
real _argR120_1_;

// file "Z:/SIdesign/NS1ellip3W//source/bsimcmg_body.include", line 118
real _argR120_2_;

// file "Z:/SIdesign/NS1ellip3W//source/bsimcmg_body.include", line 118
real _argR121_1_;

// file "Z:/SIdesign/NS1ellip3W//source/bsimcmg_body.include", line 118
real _argR122_1_;

// file "Z:/SIdesign/NS1ellip3W//source/bsimcmg_body.include", line 118
real _argR122_2_;

// file "Z:/SIdesign/NS1ellip3W//source/bsimcmg_body.include", line 118
real _argR123_1_;

// file "Z:/SIdesign/NS1ellip3W//source/bsimcmg_body.include", line 118
real _argR124_1_;

// file "Z:/SIdesign/NS1ellip3W//source/bsimcmg_body.include", line 118
real _argR124_2_;

// file "Z:/SIdesign/NS1ellip3W//source/bsimcmg_body.include", line 118
real _argR125_1_;

// file "Z:/SIdesign/NS1ellip3W//source/bsimcmg_body.include", line 118
real _argR126_1_;

// file "Z:/SIdesign/NS1ellip3W//source/bsimcmg_body.include", line 118
real _argR127_1_;

// file "Z:/SIdesign/NS1ellip3W//source/bsimcmg_body.include", line 118
real _argR128_1_;

// file "Z:/SIdesign/NS1ellip3W//source/bsimcmg_body.include", line 118
real _argR129_1_;

// file "Z:/SIdesign/NS1ellip3W//source/bsimcmg_body.include", line 118
real _argR130_1_;

// file "Z:/SIdesign/NS1ellip3W//source/bsimcmg_body.include", line 118
real _argR131_1_;

// file "Z:/SIdesign/NS1ellip3W//source/bsimcmg_body.include", line 118
real _argR132_1_;

// file "Z:/SIdesign/NS1ellip3W//source/bsimcmg_body.include", line 118
real _argR132_2_;

// file "Z:/SIdesign/NS1ellip3W//source/bsimcmg_body.include", line 118
real _argR133_1_;

// file "Z:/SIdesign/NS1ellip3W//source/bsimcmg_body.include", line 118
real _argR134_1_;

// file "Z:/SIdesign/NS1ellip3W//source/bsimcmg_body.include", line 118
real _argR135_1_;

// file "Z:/SIdesign/NS1ellip3W//source/bsimcmg_body.include", line 118
real _argR136_1_;

// file "Z:/SIdesign/NS1ellip3W//source/bsimcmg_body.include", line 118
real _argR137_1_;

// file "Z:/SIdesign/NS1ellip3W//source/bsimcmg_body.include", line 118
real _argR138_1_;

// file "Z:/SIdesign/NS1ellip3W//source/bsimcmg_body.include", line 118
real _argR138_2_;

// file "Z:/SIdesign/NS1ellip3W//source/bsimcmg_body.include", line 118
real _argR139_1_;

// file "Z:/SIdesign/NS1ellip3W//source/bsimcmg_body.include", line 118
real _argR140_1_;

// file "Z:/SIdesign/NS1ellip3W//source/bsimcmg_body.include", line 118
real _argR141_1_;

// file "Z:/SIdesign/NS1ellip3W//source/bsimcmg_body.include", line 118
real _argR142_1_;

// file "Z:/SIdesign/NS1ellip3W//source/bsimcmg_body.include", line 118
real _argR143_1_;

// file "Z:/SIdesign/NS1ellip3W//source/bsimcmg_body.include", line 118
real _argR143_2_;

// file "Z:/SIdesign/NS1ellip3W//source/bsimcmg_body.include", line 118
real _argR144_1_;

// file "Z:/SIdesign/NS1ellip3W//source/bsimcmg_body.include", line 118
real _argR144_2_;

// file "Z:/SIdesign/NS1ellip3W//source/bsimcmg_body.include", line 118
real _argR145_1_;

// file "Z:/SIdesign/NS1ellip3W//source/bsimcmg_body.include", line 118
real _argR145_2_;

// file "Z:/SIdesign/NS1ellip3W//source/bsimcmg_body.include", line 118
real _argR146_1_;

// file "Z:/SIdesign/NS1ellip3W//source/bsimcmg_body.include", line 118
real _argR146_2_;

// file "Z:/SIdesign/NS1ellip3W//source/bsimcmg_body.include", line 118
real _argR147_1_;

// file "Z:/SIdesign/NS1ellip3W//source/bsimcmg_body.include", line 118
real _argR148_1_;

// file "Z:/SIdesign/NS1ellip3W//source/bsimcmg_body.include", line 118
real _argR149_1_;

// file "Z:/SIdesign/NS1ellip3W//source/bsimcmg_body.include", line 118
real _argR150_1_;

// file "Z:/SIdesign/NS1ellip3W//source/bsimcmg_body.include", line 118
real _argR151_1_;

// file "Z:/SIdesign/NS1ellip3W//source/bsimcmg_body.include", line 118
real _argR152_1_;

// file "Z:/SIdesign/NS1ellip3W//source/bsimcmg_body.include", line 118
real _argR153_1_;

// file "Z:/SIdesign/NS1ellip3W//source/bsimcmg_body.include", line 118
real _argR154_1_;

// file "Z:/SIdesign/NS1ellip3W//source/bsimcmg_body.include", line 118
real _argR155_1_;

// file "Z:/SIdesign/NS1ellip3W//source/bsimcmg_body.include", line 118
real _argR156_1_;

// file "Z:/SIdesign/NS1ellip3W//source/bsimcmg_body.include", line 118
real _argR156_2_;

// file "Z:/SIdesign/NS1ellip3W//source/bsimcmg_body.include", line 118
real _argR157_1_;

// file "Z:/SIdesign/NS1ellip3W//source/bsimcmg_body.include", line 118
real _argR158_1_;

// file "Z:/SIdesign/NS1ellip3W//source/bsimcmg_body.include", line 118
real _argR159_1_;

// file "Z:/SIdesign/NS1ellip3W//source/bsimcmg_body.include", line 118
real _argR160_1_;

// file "Z:/SIdesign/NS1ellip3W//source/bsimcmg_body.include", line 118
real _argR161_1_;

// file "Z:/SIdesign/NS1ellip3W//source/bsimcmg_body.include", line 118
real _argR162_1_;

// file "Z:/SIdesign/NS1ellip3W//source/bsimcmg_body.include", line 118
real _argR163_1_;

// file "Z:/SIdesign/NS1ellip3W//source/bsimcmg_body.include", line 118
real _argR164_1_;

// file "Z:/SIdesign/NS1ellip3W//source/bsimcmg_body.include", line 118
real _argR165_1_;

// file "Z:/SIdesign/NS1ellip3W//source/bsimcmg_body.include", line 118
real _argR166_1_;

// file "Z:/SIdesign/NS1ellip3W//source/bsimcmg_body.include", line 118
real _argR167_1_;

// file "Z:/SIdesign/NS1ellip3W//source/bsimcmg_body.include", line 118
real _argR168_1_;

// file "Z:/SIdesign/NS1ellip3W//source/bsimcmg_body.include", line 118
real _argR169_1_;

// file "Z:/SIdesign/NS1ellip3W//source/bsimcmg_body.include", line 118
real _argR170_1_;

// file "Z:/SIdesign/NS1ellip3W//source/bsimcmg_body.include", line 118
real _argR170_2_;

// file "Z:/SIdesign/NS1ellip3W//source/bsimcmg_body.include", line 118
real _argR171_1_;

// file "Z:/SIdesign/NS1ellip3W//source/bsimcmg_body.include", line 118
real _argR171_2_;

// file "Z:/SIdesign/NS1ellip3W//source/bsimcmg_body.include", line 118
real _argR172_1_;

// file "Z:/SIdesign/NS1ellip3W//source/bsimcmg_body.include", line 118
real _argR173_1_;

// file "Z:/SIdesign/NS1ellip3W//source/bsimcmg_body.include", line 118
real _argR173_2_;

// file "Z:/SIdesign/NS1ellip3W//source/bsimcmg_body.include", line 118
real _argR173_3_;

// file "Z:/SIdesign/NS1ellip3W//source/bsimcmg_body.include", line 118
real _argR174_1_;

// file "Z:/SIdesign/NS1ellip3W//source/bsimcmg_body.include", line 118
real _argR175_1_;

// file "Z:/SIdesign/NS1ellip3W//source/bsimcmg_body.include", line 118
real _argR176_1_;

// file "Z:/SIdesign/NS1ellip3W//source/bsimcmg_body.include", line 118
real _argR177_1_;

// file "Z:/SIdesign/NS1ellip3W//source/bsimcmg_body.include", line 118
real _argR178_1_;

// file "Z:/SIdesign/NS1ellip3W//source/bsimcmg_body.include", line 118
real _argR179_1_;

// file "Z:/SIdesign/NS1ellip3W//source/bsimcmg_body.include", line 118
real _argR180_1_;

// file "Z:/SIdesign/NS1ellip3W//source/bsimcmg_body.include", line 118
real _argR181_1_;

// file "Z:/SIdesign/NS1ellip3W//source/bsimcmg_body.include", line 118
real _argR182_1_;

// file "Z:/SIdesign/NS1ellip3W//source/bsimcmg_body.include", line 118
real _argR182_2_;

// file "Z:/SIdesign/NS1ellip3W//source/bsimcmg_body.include", line 118
real _argR183_1_;

// file "Z:/SIdesign/NS1ellip3W//source/bsimcmg_body.include", line 118
real _argR184_1_;

// file "Z:/SIdesign/NS1ellip3W//source/bsimcmg_body.include", line 118
real _argR184_2_;

// file "Z:/SIdesign/NS1ellip3W//source/bsimcmg_body.include", line 118
real _argR185_1_;

// file "Z:/SIdesign/NS1ellip3W//source/bsimcmg_body.include", line 118
real _argR186_1_;

// file "Z:/SIdesign/NS1ellip3W//source/bsimcmg_body.include", line 118
real _argR186_2_;

// file "Z:/SIdesign/NS1ellip3W//source/bsimcmg_body.include", line 118
real _argR187_1_;

// file "Z:/SIdesign/NS1ellip3W//source/bsimcmg_body.include", line 118
real _argR188_1_;

// file "Z:/SIdesign/NS1ellip3W//source/bsimcmg_body.include", line 118
real _argR189_1_;

// file "Z:/SIdesign/NS1ellip3W//source/bsimcmg_body.include", line 118
real _argR189_2_;

// file "Z:/SIdesign/NS1ellip3W//source/bsimcmg_body.include", line 118
real _argR190_1_;

// file "Z:/SIdesign/NS1ellip3W//source/bsimcmg_body.include", line 118
real _argR191_1_;

// file "Z:/SIdesign/NS1ellip3W//source/bsimcmg_body.include", line 118
real _argR192_1_;

// file "Z:/SIdesign/NS1ellip3W//source/bsimcmg_body.include", line 118
real _argR192_2_;

// file "Z:/SIdesign/NS1ellip3W//source/bsimcmg_body.include", line 118
real _argR193_1_;

// file "Z:/SIdesign/NS1ellip3W//source/bsimcmg_body.include", line 118
real _argR194_1_;

// file "Z:/SIdesign/NS1ellip3W//source/bsimcmg_body.include", line 118
real _argR195_1_;

// file "Z:/SIdesign/NS1ellip3W//source/bsimcmg_body.include", line 118
real _argR195_2_;

// file "Z:/SIdesign/NS1ellip3W//source/bsimcmg_body.include", line 118
real _argR196_1_;

// file "Z:/SIdesign/NS1ellip3W//source/bsimcmg_body.include", line 118
real _argR197_1_;

// file "Z:/SIdesign/NS1ellip3W//source/bsimcmg_body.include", line 118
real _argR198_1_;

// file "Z:/SIdesign/NS1ellip3W//source/bsimcmg_body.include", line 118
real _argR199_1_;

// file "Z:/SIdesign/NS1ellip3W//source/bsimcmg_body.include", line 118
real _argR200_1_;

// file "Z:/SIdesign/NS1ellip3W//source/bsimcmg_body.include", line 118
real _argR201_1_;

// file "Z:/SIdesign/NS1ellip3W//source/bsimcmg_body.include", line 118
real _argR202_1_;

// file "Z:/SIdesign/NS1ellip3W//source/bsimcmg_body.include", line 118
real _argR203_1_;

// file "Z:/SIdesign/NS1ellip3W//source/bsimcmg_body.include", line 118
real _argR204_1_;

// file "Z:/SIdesign/NS1ellip3W//source/bsimcmg_body.include", line 118
real _argR205_1_;

// file "Z:/SIdesign/NS1ellip3W//source/bsimcmg_body.include", line 118
real _argR206_1_;

// file "Z:/SIdesign/NS1ellip3W//source/bsimcmg_body.include", line 118
real _argR207_1_;

// file "Z:/SIdesign/NS1ellip3W//source/bsimcmg_body.include", line 118
real _argR208_1_;

// file "Z:/SIdesign/NS1ellip3W//source/bsimcmg_body.include", line 118
real _argR209_1_;

// file "Z:/SIdesign/NS1ellip3W//source/bsimcmg_body.include", line 118
real _argR210_1_;

// file "Z:/SIdesign/NS1ellip3W//source/bsimcmg_body.include", line 118
real _argR211_1_;

// file "Z:/SIdesign/NS1ellip3W//source/bsimcmg_body.include", line 118
real _argR212_1_;

// file "Z:/SIdesign/NS1ellip3W//source/bsimcmg_body.include", line 118
real _argR213_1_;

// file "Z:/SIdesign/NS1ellip3W//source/bsimcmg_body.include", line 118
real _argR214_1_;

// file "Z:/SIdesign/NS1ellip3W//source/bsimcmg_body.include", line 118
real _argR215_1_;

// file "Z:/SIdesign/NS1ellip3W//source/bsimcmg_body.include", line 118
real _argR216_1_;

// file "Z:/SIdesign/NS1ellip3W//source/bsimcmg_body.include", line 118
real _argR217_1_;

// file "Z:/SIdesign/NS1ellip3W//source/bsimcmg_body.include", line 118
real _argR218_1_;

// file "Z:/SIdesign/NS1ellip3W//source/bsimcmg_body.include", line 118
real _argR219_1_;

// file "Z:/SIdesign/NS1ellip3W//source/bsimcmg_body.include", line 118
real _argR220_1_;

// file "Z:/SIdesign/NS1ellip3W//source/bsimcmg_body.include", line 118
real _argR221_1_;

// file "Z:/SIdesign/NS1ellip3W//source/bsimcmg_body.include", line 118
real _argR222_1_;

// file "Z:/SIdesign/NS1ellip3W//source/bsimcmg_body.include", line 118
real _argR223_1_;

// file "Z:/SIdesign/NS1ellip3W//source/bsimcmg_body.include", line 118
real _argR224_1_;

// file "Z:/SIdesign/NS1ellip3W//source/bsimcmg_body.include", line 118
real _argR225_1_;

// file "Z:/SIdesign/NS1ellip3W//source/bsimcmg_body.include", line 118
real _argR226_1_;

// file "Z:/SIdesign/NS1ellip3W//source/bsimcmg_body.include", line 118
real _argR227_1_;

// file "Z:/SIdesign/NS1ellip3W//source/bsimcmg_body.include", line 118
real _argR228_1_;

// file "Z:/SIdesign/NS1ellip3W//source/bsimcmg_body.include", line 118
real _argR229_1_;

// file "Z:/SIdesign/NS1ellip3W//source/bsimcmg_body.include", line 118
real _argR230_1_;

// file "Z:/SIdesign/NS1ellip3W//source/bsimcmg_body.include", line 118
real _argR231_1_;

// file "Z:/SIdesign/NS1ellip3W//source/bsimcmg_body.include", line 118
real _argR232_1_;

// file "Z:/SIdesign/NS1ellip3W//source/bsimcmg_body.include", line 118
real _argR233_1_;

// file "Z:/SIdesign/NS1ellip3W//source/bsimcmg_body.include", line 118
real _argR234_1_;

// file "Z:/SIdesign/NS1ellip3W//source/bsimcmg_body.include", line 118
real _argR235_1_;

// file "Z:/SIdesign/NS1ellip3W//source/bsimcmg_body.include", line 118
real _argR236_1_;

// file "Z:/SIdesign/NS1ellip3W//source/bsimcmg_body.include", line 118
real _argR237_1_;

// file "Z:/SIdesign/NS1ellip3W//source/bsimcmg_body.include", line 118
real _argR238_1_;

// file "Z:/SIdesign/NS1ellip3W//source/bsimcmg_body.include", line 118
real _argR239_1_;

// file "Z:/SIdesign/NS1ellip3W//source/bsimcmg_body.include", line 118
real _argR240_1_;

// file "Z:/SIdesign/NS1ellip3W//source/bsimcmg_body.include", line 118
real _argR241_1_;

// file "Z:/SIdesign/NS1ellip3W//source/bsimcmg_body.include", line 118
real _argR242_1_;

// file "Z:/SIdesign/NS1ellip3W//source/bsimcmg_body.include", line 118
real _argR243_1_;

// file "Z:/SIdesign/NS1ellip3W//source/bsimcmg_body.include", line 118
real _argR244_1_;

// file "Z:/SIdesign/NS1ellip3W//source/bsimcmg_body.include", line 118
real _argR245_1_;

// file "Z:/SIdesign/NS1ellip3W//source/bsimcmg_body.include", line 118
real _argR246_1_;

// file "Z:/SIdesign/NS1ellip3W//source/bsimcmg_body.include", line 118
real _argR247_1_;

// file "Z:/SIdesign/NS1ellip3W//source/bsimcmg_body.include", line 118
real _argR248_1_;

// file "Z:/SIdesign/NS1ellip3W//source/bsimcmg_body.include", line 118
real _argR249_1_;

// file "Z:/SIdesign/NS1ellip3W//source/bsimcmg_body.include", line 118
real _argR250_1_;

// file "Z:/SIdesign/NS1ellip3W//source/bsimcmg_body.include", line 118
real _argR251_1_;

// file "Z:/SIdesign/NS1ellip3W//source/bsimcmg_body.include", line 118
real _argR252_1_;

// file "Z:/SIdesign/NS1ellip3W//source/bsimcmg_body.include", line 118
real _argR253_1_;

// file "Z:/SIdesign/NS1ellip3W//source/bsimcmg_body.include", line 118
real _argR254_1_;

// file "Z:/SIdesign/NS1ellip3W//source/bsimcmg_body.include", line 118
real _argR255_1_;

// file "Z:/SIdesign/NS1ellip3W//source/bsimcmg_body.include", line 118
real _argR256_1_;

// file "Z:/SIdesign/NS1ellip3W//source/bsimcmg_body.include", line 118
real _argR257_1_;

// file "Z:/SIdesign/NS1ellip3W//source/bsimcmg_body.include", line 118
real _argR258_1_;

// file "Z:/SIdesign/NS1ellip3W//source/bsimcmg_body.include", line 118
real _argR259_1_;

// file "Z:/SIdesign/NS1ellip3W//source/bsimcmg_body.include", line 118
real _argR260_1_;

// file "Z:/SIdesign/NS1ellip3W//source/bsimcmg_body.include", line 118
real _argR261_1_;

// file "Z:/SIdesign/NS1ellip3W//source/bsimcmg_body.include", line 118
real _argR262_1_;

// file "Z:/SIdesign/NS1ellip3W//source/bsimcmg_body.include", line 118
real _argR263_1_;

// file "Z:/SIdesign/NS1ellip3W//source/bsimcmg_body.include", line 118
real _argR264_1_;

// file "Z:/SIdesign/NS1ellip3W//source/bsimcmg_body.include", line 118
real _argR265_1_;

// file "Z:/SIdesign/NS1ellip3W//source/bsimcmg_body.include", line 118
real _argR266_1_;

// file "Z:/SIdesign/NS1ellip3W//source/bsimcmg_body.include", line 118
real _argR267_1_;

// file "Z:/SIdesign/NS1ellip3W//source/bsimcmg_body.include", line 118
real _argR268_1_;

// file "Z:/SIdesign/NS1ellip3W//source/bsimcmg_body.include", line 118
real _argR269_1_;

// file "Z:/SIdesign/NS1ellip3W//source/bsimcmg_body.include", line 118
real _argR270_1_;

// file "Z:/SIdesign/NS1ellip3W//source/bsimcmg_body.include", line 118
real _argR271_1_;

// file "Z:/SIdesign/NS1ellip3W//source/bsimcmg_body.include", line 118
real _argR272_1_;

// file "Z:/SIdesign/NS1ellip3W//source/bsimcmg_body.include", line 118
real _argR273_1_;

// file "Z:/SIdesign/NS1ellip3W//source/bsimcmg_body.include", line 118
real _argR274_1_;

// file "Z:/SIdesign/NS1ellip3W//source/bsimcmg_body.include", line 118
real _argR275_1_;

// file "Z:/SIdesign/NS1ellip3W//source/bsimcmg_body.include", line 118
real _argR276_1_;

// file "Z:/SIdesign/NS1ellip3W//source/bsimcmg_body.include", line 118
real _argR277_1_;

// file "Z:/SIdesign/NS1ellip3W//source/bsimcmg_body.include", line 118
real _argR278_1_;

// file "Z:/SIdesign/NS1ellip3W//source/bsimcmg_body.include", line 118
real _argR279_1_;

// file "Z:/SIdesign/NS1ellip3W//source/bsimcmg_body.include", line 118
real _argR280_1_;

// file "Z:/SIdesign/NS1ellip3W//source/bsimcmg_body.include", line 118
real _argR281_1_;

// file "Z:/SIdesign/NS1ellip3W//source/bsimcmg_body.include", line 118
real _argR282_1_;

// file "Z:/SIdesign/NS1ellip3W//source/bsimcmg_body.include", line 118
real _argR283_1_;

// file "Z:/SIdesign/NS1ellip3W//source/bsimcmg_body.include", line 118
real _argR284_1_;

// file "Z:/SIdesign/NS1ellip3W//source/bsimcmg_body.include", line 118
real _argR285_1_;

// file "Z:/SIdesign/NS1ellip3W//source/bsimcmg_body.include", line 118
real _argR286_1_;

// file "Z:/SIdesign/NS1ellip3W//source/bsimcmg_body.include", line 118
real _argR287_1_;

// file "Z:/SIdesign/NS1ellip3W//source/bsimcmg_body.include", line 118
real _argR288_1_;

// file "Z:/SIdesign/NS1ellip3W//source/bsimcmg_body.include", line 118
real _argR289_1_;

// file "Z:/SIdesign/NS1ellip3W//source/bsimcmg_body.include", line 118
real _argR290_1_;

// file "Z:/SIdesign/NS1ellip3W//source/bsimcmg_body.include", line 118
real _argR291_1_;

// file "Z:/SIdesign/NS1ellip3W//source/bsimcmg_body.include", line 118
real _argR292_1_;

// file "Z:/SIdesign/NS1ellip3W//source/bsimcmg_body.include", line 118
real _argR293_1_;

// file "Z:/SIdesign/NS1ellip3W//source/bsimcmg_body.include", line 118
real _argR294_1_;

// file "Z:/SIdesign/NS1ellip3W//source/bsimcmg_body.include", line 118
real _argR295_1_;

// file "Z:/SIdesign/NS1ellip3W//source/bsimcmg_body.include", line 118
real _argR296_1_;

// file "Z:/SIdesign/NS1ellip3W//source/bsimcmg_body.include", line 118
real _argR297_1_;
analog begin
    begin : CMGBiasIndepCalc
        qid = 0.0;
        qis = 0.0;
        qba = 0.0;
        T11 = 0.0;
        T12 = 0.0;
        ids = 0.0;
        sigvds = 0.0;
        Iii = 0.0;
        qd = 0.0;
        qg = 0.0;
        qs = 0.0;
        qb = 0.0;
        Weff0 = 0.0;
        WeffCV0 = 0.0;
        CJS_t = 0.0;
        CJSWS_t = 0.0;
        CJSWGS_t = 0.0;
        CJD_t = 0.0;
        CJSWD_t = 0.0;
        CJSWGD_t = 0.0;
        PBS_t = 0.0;
        PBSWS_t = 0.0;
        PBSWGS_t = 0.0;
        PBD_t = 0.0;
        PBSWD_t = 0.0;
        PBSWGD_t = 0.0;
        JSS_t = 0.0;
        JSWS_t = 0.0;
        JSWGS_t = 0.0;
        JSD_t = 0.0;
        JSWD_t = 0.0;
        JSWGD_t = 0.0;
        JTSS_t = 0.0;
        JTSSWS_t = 0.0;
        JTSSWGS_t = 0.0;
        JTSD_t = 0.0;
        JTSSWD_t = 0.0;
        JTSSWGD_t = 0.0;
        NJTS_t = 0.0;
        NJTSSW_t = 0.0;
        NJTSSWG_t = 0.0;
        NJTSD_t = 0.0;
        NJTSSWD_t = 0.0;
        NJTSSWGD_t = 0.0;
        Ies = 0.0;
        Ied = 0.0;
        Czbs = 0.0;
        Czbssw = 0.0;
        Czbsswg = 0.0;
        Czbd = 0.0;
        Czbdsw = 0.0;
        Czbdswg = 0.0;
        Qes = 0.0;
        Qed = 0.0;
        Qeg = 0.0;
        Isbs = 0.0;
        Isbd = 0.0;
        Nvtms = 0.0;
        Nvtmd = 0.0;
        SslpRev = 0.0;
        IVjsmRev = 0.0;
        VjsmRev = 0.0;
        SslpFwd = 0.0;
        IVjsmFwd = 0.0;
        VjsmFwd = 0.0;
        DslpRev = 0.0;
        IVjdmRev = 0.0;
        VjdmRev = 0.0;
        DslpFwd = 0.0;
        IVjdmFwd = 0.0;
        VjdmFwd = 0.0;
        XExpBVS = 0.0;
        XExpBVD = 0.0;
        idsgen = 0.0;
        q0 = 0.0;
        Tcen = 0.0;
        MTcen = 0.0;
        Rdrain = 0.0;
        Rsource = 0.0;
        Cfr_geo = 0.0;
        igbinv = 0.0;
        igbs = 0.0;
        igbd = 0.0;
        igbacc = 0.0;
        igcs = 0.0;
        igcd = 0.0;
        igidl = 0.0;
        igisl = 0.0;
        igs = 0.0;
        igd = 0.0;
        cox_acc = 0.0;
        CGSO_i = 0.0;
        CGDO_i = 0.0;
        qb_acc = 0.0;
        qg_acc = 0.0;
        qgs_fr = 0.0;
        qgd_fr = 0.0;
        qds_fr = 0.0;
        qgs_parasitic = 0.0;
        qgd_parasitic = 0.0;
        FNPowerAt1Hz = 0.0;
        Gtnoi = 0.0;
        gspr = 0.0;
        gdpr = 0.0;
        Dr = 1.0;
        CDSCDR_i = 0.0;
        ETA0R_i = 0.0;
        VSAT1R_i = 0.0;
        VSAT1R_t = 0.0;
        MEXPR_i = 0.0;
        MEXPR_t = 0.0;
        PTWGR_i = 0.0;
        PTWGR_t = 0.0;
        PDIBL1R_i = 0.0;
        PDIBL2R_i = 0.0;
        PHIBE_i = 0.0;
        K1_i = 0.0;
        K11_i = 0.0;
        K2SAT_i = 0.0;
        K2SAT1_i = 0.0;
        KSATIVR_i = 0.0;
        K2_i = 0.0;
        K21_i = 0.0;
        UC_i = 0.0;
        UC1_i = 0.0;
        UC_t = 0.0;
        U0R_i = 0.0;
        UPR_i = 0.0;
        EUR_i = 0.0;
        ATR_i = 0.0;
        CITR_i = 0.0;
        ETA0R_i = 0.0;
        DVTP0_i = 0.0;
        DVTP1_i = 0.0;
        PDIBL2R_i = 0.0;
        PCLMR_i = 0.0;
        LeffCV_acc = 0.0;
        RDDRR_t = 0.0;
        RSDRR_t = 0.0;
        Rdsi = 0.0;
        T3 = 0.0;
        Tcen0 = 0.0;
        veseff = 0.0;
        U0R_t = 0.0;
        UAR_t = 0.0;
        UCR_t = 0.0;
        UDR_t = 0.0;
        VSAT_a = 0.0;
        DVTSHIFTR_i = 0.0;
        UA1R_i = 0.0;
        UAR_i = 0.0;
        UC1R_i = 0.0;
        UCR_i = 0.0;
        UD1R_i = 0.0;
        UDR_i = 0.0;
        UTER_i = 0.0;
        UTLR_i = 0.0;
        VSATR_i = 0.0;
        VSATR_t = 0.0;
        u0r = 0.0;
        sid = 0.0;
        ctnoi = 0.0;
        sf = 0.0;
        C0 = 0.0;
        gamma = 0.0;
        delta = 0.0;
        ggeltd = 0.0;
        qm = 1.0;
        Cins = 1.0;
        Ach = 1.0;
        Weff_UFCM = 1.0;
        qdep = -1.0;
        rc = 1.0;
        vth_fixed_factor_Sub = 1.0;
        vth_fixed_factor_SI = 1.0;
        qi_acc_for_QM = 0.0;
        fieldnormalizationfactor = 0.0;
        auxQMfact = 0.0;
        QMFACTORCVfinal = 0.0;
        psipclamp = 1.0;
        sqrtpsip = 1.0;
        nq = 1.0;
        F0 = 0.0;
        e0 = 0.0;
        e1 = 0.0;
        e2 = 0.0;
        Qdep_ov_Cins = 0.0;
        if (TYPE == 1) begin
            devsign = 1;
        end
        else begin
            devsign = -1;
        end
        epssub = EPSRSUB * 8.8542e-12;
        epssp = EPSRSP * 8.8542e-12;
        cbox = EPSROX * 8.8542e-12 / EOTBOX;
        epsratio = EPSRSUB / EPSROX;
        if ($port_connected(t) == 1) begin
            if (SHMOD == 0) begin
                if (SH_WARN == 1) begin
                    $strobe("The optional 5th terminal is present but not active because SHMOD=0.");
                end
            end
        end
        mx = 0.916 * 9.1100000000000003e-31;
        mxprime = 0.19 * 9.1100000000000003e-31;
        md = 0.19 * 9.1100000000000003e-31;
        mdprime = 0.417 * 9.1100000000000003e-31;
        gprime = 4.0;
        gfactor = 2.0;
        Lg = L + XL;
        deltaL = LINT + LL * pow(Lg,-LLN);
        deltaL1 = LINT + LL * pow(Lg + DLBIN,-LLN);
        deltaLCV = DLC + LLC * pow(Lg,-LLN);
        Leff = Lg - 2.0 * deltaL;
        Leff1 = Lg + DLBIN - 2.0 * deltaL1;
        LeffCV = Lg - 2.0 * deltaLCV;
        if (BULKMOD != 0) LeffCV_acc = LeffCV - DLCACC;
        NFINtotal = NFIN * NF;
        if (Leff <= 0.0) begin
            $strobe("Fatal: Leff = %e is not positive.",Leff);
            $finish(0);
        end
        else if (Leff <= 1e-09) begin
            $strobe("Warning: Leff = %e <= 1.0e-9.",Leff);
        end
        if (Leff1 <= 0.0) begin
            $strobe("Fatal: Leff1 = %e is not positive.",Leff1);
            $finish(0);
        end
        else if (Leff1 <= 1e-09) begin
            $strobe("Warning: Leff1 = %e <= 1.0e-9.",Leff1);
        end
        Inv_L = 1e-06 / (Leff1);
        Inv_NFIN = 1.0 / NFIN;
        Inv_LNFIN = 1e-06 / (Leff1 * NFIN);
        NBODY_i = NBODY + Inv_L * LNBODY + Inv_NFIN * NNBODY + Inv_LNFIN * PNBODY;
        if (NBODYN1 != 0.0) begin
            _argR3_1_ = 1.0 + NFIN / NBODYN2;
            begin : llnE03
                real lln;
                real x_f2;

                x_f2 = _argR3_1_;
                lln = ln(max(x_f2,9.9999999999999996e-39));
                llnE03 = lln;
            end
            NBODY_i = NBODY_i * (1.0 + NBODYN1 / NFIN * llnE03);
        end
        case (GEOMOD)
        0 : begin
            if (!$param_given(TFIN_TOP) || !$param_given(TFIN_BASE)) begin
                Weff_UFCM = 2.0 * HFIN;
                Cins = Weff_UFCM * EPSROX * 8.8542e-12 / EOT;
                Ach = HFIN * TFIN;
                rc = (2.0 * Cins / (Weff_UFCM * Weff_UFCM * epssub / Ach));
                Qdep_ov_Cins = -1.6021899999999999e-19 * NBODY_i * Ach / Cins;
            end
            else begin
                Weff_UFCM = 2.0 * sqrt(HFIN * HFIN + (TFIN_TOP - TFIN_BASE) * (TFIN_TOP - TFIN_BASE) / 4.0);
                Cins = Weff_UFCM * EPSROX * 8.8542e-12 / EOT;
                Ach = HFIN * (TFIN_TOP + TFIN_BASE) / 2.0;
                rc = (2.0 * Cins / (Weff_UFCM * Weff_UFCM * epssub / Ach));
                Qdep_ov_Cins = -1.6021899999999999e-19 * NBODY_i * Ach / Cins;
            end
        end
        1 : begin
            if (!$param_given(TFIN_TOP) || !$param_given(TFIN_BASE)) begin
                Weff_UFCM = 2.0 * HFIN + TFIN;
                Cins = Weff_UFCM * EPSROX * 8.8542e-12 / EOT;
                Ach = HFIN * TFIN;
                rc = (2.0 * Cins / (Weff_UFCM * Weff_UFCM * epssub / Ach));
                Qdep_ov_Cins = -1.6021899999999999e-19 * NBODY_i * Ach / Cins;
            end
            else begin
                Weff_UFCM = 2.0 * sqrt(HFIN * HFIN + (TFIN_TOP - TFIN_BASE) * (TFIN_TOP - TFIN_BASE) / 4.0) + TFIN_TOP;
                Cins = Weff_UFCM * EPSROX * 8.8542e-12 / EOT;
                Ach = HFIN * (TFIN_TOP + TFIN_BASE) / 2.0;
                rc = (2.0 * Cins / (Weff_UFCM * Weff_UFCM * epssub / Ach));
                Qdep_ov_Cins = -1.6021899999999999e-19 * NBODY_i * Ach / Cins;
            end
        end
        2 : begin
            if (!$param_given(TFIN_TOP) || !$param_given(TFIN_BASE)) begin
                Weff_UFCM = 2.0 * HFIN + 2.0 * TFIN;
                Cins = Weff_UFCM * EPSROX * 8.8542e-12 / EOT;
                Ach = HFIN * TFIN;
                rc = (2.0 * Cins / (Weff_UFCM * Weff_UFCM * epssub / Ach));
                Qdep_ov_Cins = -1.6021899999999999e-19 * NBODY_i * Ach / Cins;
            end
            else begin
                Weff_UFCM = 2.0 * sqrt(HFIN * HFIN + (TFIN_TOP - TFIN_BASE) * (TFIN_TOP - TFIN_BASE) / 4.0) + TFIN_TOP + TFIN_BASE;
                Cins = Weff_UFCM * EPSROX * 8.8542e-12 / EOT;
                Ach = HFIN * (TFIN_TOP + TFIN_BASE) / 2.0;
                rc = (2.0 * Cins / (Weff_UFCM * Weff_UFCM * epssub / Ach));
                Qdep_ov_Cins = -1.6021899999999999e-19 * NBODY_i * Ach / Cins;
            end
        end
        3 : begin
            Weff_UFCM = 3.141592653589793 * D;
            Cins = 2.0 * 3.141592653589793 * EPSROX * 8.8542e-12 / ln(1.0 + 2.0 * EOT / D);
            Ach = 3.141592653589793 * D * D / 4.0;
            rc = (2.0 * Cins / (Weff_UFCM * Weff_UFCM * epssub / Ach));
            Qdep_ov_Cins = -1.6021899999999999e-19 * NBODY_i * Ach / Cins;
        end
        4 : begin
            Weff_UFCM = W_UFCM;
            Cins = CINS_UFCM;
            Ach = ACH_UFCM;
            rc = (2.0 * Cins / (Weff_UFCM * Weff_UFCM * epssub / Ach));
            Qdep_ov_Cins = -1.6021899999999999e-19 * NBODY_i * Ach / Cins;
        end
        endcase

        cox = Cins / Weff_UFCM;
        if (BULKMOD != 0) begin
            cox_acc = cox * EOT / EOTACC;
        end
        Weff0 = Weff_UFCM - DELTAW;
        WeffCV0 = Weff_UFCM - DELTAWCV;
        scl = sqrt((epssub * Ach / Cins) * (1.0 + Ach * Cins / (2.0 * epssub * Weff_UFCM * Weff_UFCM)));
        PHIG_i = PHIG + Inv_L * LPHIG + Inv_NFIN * NPHIG + Inv_LNFIN * PPHIG;
        NGATE_i = NGATE + Inv_L * LNGATE + Inv_NFIN * NNGATE + Inv_LNFIN * PNGATE;
        CIT_i = CIT + Inv_L * LCIT + Inv_NFIN * NCIT + Inv_LNFIN * PCIT;
        CDSC_i = CDSC + Inv_L * LCDSC + Inv_NFIN * NCDSC + Inv_LNFIN * PCDSC;
        CDSCD_i = CDSCD + Inv_L * LCDSCD + Inv_NFIN * NCDSCD + Inv_LNFIN * PCDSCD;
        DVT0_i = DVT0 + Inv_L * LDVT0 + Inv_NFIN * NDVT0 + Inv_LNFIN * PDVT0;
        DVT1_i = DVT1 + Inv_L * LDVT1 + Inv_NFIN * NDVT1 + Inv_LNFIN * PDVT1;
        DVT1SS_i = DVT1SS + Inv_L * LDVT1SS + Inv_NFIN * NDVT1SS + Inv_LNFIN * PDVT1SS;
        PHIN_i = PHIN + Inv_L * LPHIN + Inv_NFIN * NPHIN + Inv_LNFIN * PPHIN;
        ETA0_i = ETA0 + Inv_L * LETA0 + Inv_NFIN * NETA0 + Inv_LNFIN * PETA0;
        DSUB_i = DSUB + Inv_L * LDSUB + Inv_NFIN * NDSUB + Inv_LNFIN * PDSUB;
        K1RSCE_i = K1RSCE + Inv_L * LK1RSCE + Inv_NFIN * NK1RSCE + Inv_LNFIN * PK1RSCE;
        LPE0_i = LPE0 + Inv_L * LLPE0 + Inv_NFIN * NLPE0 + Inv_LNFIN * PLPE0;
        DVTSHIFT_i = DVTSHIFT + Inv_L * LDVTSHIFT + Inv_NFIN * NDVTSHIFT + Inv_LNFIN * PDVTSHIFT;
        K0_i = K0 + Inv_L * LK0 + Inv_NFIN * NK0 + Inv_LNFIN * PK0;
        K01_i = K01 + Inv_L * LK01 + Inv_NFIN * NK01 + Inv_LNFIN * PK01;
        K0SI_i = K0SI + Inv_L * LK0SI + Inv_NFIN * NK0SI + Inv_LNFIN * PK0SI;
        K0SI1_i = K0SI1 + Inv_L * LK0SI1 + Inv_NFIN * NK0SI1 + Inv_LNFIN * PK0SI1;
        K2SI_i = K2SI + Inv_L * LK2SI + Inv_NFIN * NK2SI + Inv_LNFIN * PK2SI;
        K2SI1_i = K2SI1 + Inv_L * LK2SI1 + Inv_NFIN * NK2SI1 + Inv_LNFIN * PK2SI1;
        K0SISAT_i = K0SISAT + Inv_L * LK0SISAT + Inv_NFIN * NK0SISAT + Inv_LNFIN * PK0SISAT;
        K0SISAT1_i = K0SISAT1 + Inv_L * LK0SISAT1 + Inv_NFIN * NK0SISAT1 + Inv_LNFIN * PK0SISAT1;
        K2SISAT_i = K2SISAT + Inv_L * LK2SISAT + Inv_NFIN * NK2SISAT + Inv_LNFIN * PK2SISAT;
        K2SISAT1_i = K2SISAT1 + Inv_L * LK2SISAT1 + Inv_NFIN * NK2SISAT1 + Inv_LNFIN * PK2SISAT1;
        if (BULKMOD != 0) begin
            if (BULKMOD == 2) begin
                K2_i = K2 + Inv_L * LK2 + Inv_NFIN * NK2 + Inv_LNFIN * PK2;
                K21_i = K21 + Inv_L * LK21 + Inv_NFIN * NK21 + Inv_LNFIN * PK21;
                K2SAT_i = K2SAT + Inv_L * LK2SAT + Inv_NFIN * NK2SAT + Inv_LNFIN * PK2SAT;
                K2SAT1_i = K2SAT1 + Inv_L * LK2SAT1 + Inv_NFIN * NK2SAT1 + Inv_LNFIN * PK2SAT1;
            end
            PHIBE_i = PHIBE + Inv_L * LPHIBE + Inv_NFIN * NPHIBE + Inv_LNFIN * PPHIBE;
            K1_i = K1 + Inv_L * LK1 + Inv_NFIN * NK1 + Inv_LNFIN * PK1;
            K11_i = K11 + Inv_L * LK11 + Inv_NFIN * NK11 + Inv_LNFIN * PK11;
        end
        QMFACTOR_i = QMFACTOR + Inv_L * LQMFACTOR + Inv_NFIN * NQMFACTOR + Inv_LNFIN * PQMFACTOR;
        QMTCENCV_i = QMTCENCV + Inv_L * LQMTCENCV + Inv_NFIN * NQMTCENCV + Inv_LNFIN * PQMTCENCV;
        QMTCENCVA_i = QMTCENCVA + Inv_L * LQMTCENCVA + Inv_NFIN * NQMTCENCVA + Inv_LNFIN * PQMTCENCVA;
        VSAT_i = VSAT + Inv_L * LVSAT + Inv_NFIN * NVSAT + Inv_LNFIN * PVSAT;
        VSAT1_i = VSAT1 + Inv_L * LVSAT1 + Inv_NFIN * NVSAT1 + Inv_LNFIN * PVSAT1;
        VSATCV_i = VSATCV + Inv_L * LVSATCV + Inv_NFIN * NVSATCV + Inv_LNFIN * PVSATCV;
        DELTAVSAT_i = DELTAVSAT + Inv_L * LDELTAVSAT + Inv_NFIN * NDELTAVSAT + Inv_LNFIN * PDELTAVSAT;
        PSAT_i = PSAT + Inv_L * LPSAT + Inv_NFIN * NPSAT + Inv_LNFIN * PPSAT;
        DELTAVSATCV_i = DELTAVSATCV + Inv_L * LDELTAVSATCV + Inv_NFIN * NDELTAVSATCV + Inv_LNFIN * PDELTAVSATCV;
        PSATCV_i = PSATCV + Inv_L * LPSATCV + Inv_NFIN * NPSATCV + Inv_LNFIN * PPSATCV;
        KSATIV_i = KSATIV + Inv_L * LKSATIV + Inv_NFIN * NKSATIV + Inv_LNFIN * PKSATIV;
        MEXP_i = MEXP + Inv_L * LMEXP + Inv_NFIN * NMEXP + Inv_LNFIN * PMEXP;
        PTWG_i = PTWG + Inv_L * LPTWG + Inv_NFIN * NPTWG + Inv_LNFIN * PPTWG;
        U0_i = U0 + Inv_L * LU0 + Inv_NFIN * NU0 + Inv_LNFIN * PU0;
        ETAMOB_i = ETAMOB + Inv_L * LETAMOB + Inv_NFIN * NETAMOB + Inv_LNFIN * PETAMOB;
        UP_i = UP + Inv_L * LUP + Inv_NFIN * NUP + Inv_LNFIN * PUP;
        UA_i = UA + Inv_L * LUA + Inv_NFIN * NUA + Inv_LNFIN * PUA;
        if (BULKMOD != 0) begin
            UC_i = UC + Inv_L * LUC + Inv_NFIN * NUC + Inv_LNFIN * PUC;
        end
        EU_i = EU + Inv_L * LEU + Inv_NFIN * NEU + Inv_LNFIN * PEU;
        UD_i = UD + Inv_L * LUD + Inv_NFIN * NUD + Inv_LNFIN * PUD;
        UCS_i = UCS + Inv_L * LUCS + Inv_NFIN * NUCS + Inv_LNFIN * PUCS;
        PCLM_i = PCLM + Inv_L * LPCLM + Inv_NFIN * NPCLM + Inv_LNFIN * PPCLM;
        PCLMG_i = PCLMG + Inv_L * LPCLMG + Inv_NFIN * NPCLMG + Inv_LNFIN * PPCLMG;
        PCLMCV_i = PCLMCV + Inv_L * LPCLMCV + Inv_NFIN * NPCLMCV + Inv_LNFIN * PPCLMCV;
        A1_i = A1 + Inv_L * LA1 + Inv_NFIN * NA1 + Inv_LNFIN * PA1;
        A11_i = A11 + Inv_L * LA11 + Inv_NFIN * NA11 + Inv_LNFIN * PA11;
        A2_i = A2 + Inv_L * LA2 + Inv_NFIN * NA2 + Inv_LNFIN * PA2;
        A21_i = A21 + Inv_L * LA21 + Inv_NFIN * NA21 + Inv_LNFIN * PA21;
        RDSW_i = RDSW + Inv_L * LRDSW + Inv_NFIN * NRDSW + Inv_LNFIN * PRDSW;
        RSW_i = RSW + Inv_L * LRSW + Inv_NFIN * NRSW + Inv_LNFIN * PRSW;
        RDW_i = RDW + Inv_L * LRDW + Inv_NFIN * NRDW + Inv_LNFIN * PRDW;
        PRWGD_i = PRWGD + Inv_L * LPRWGD + Inv_NFIN * NPRWGD + Inv_LNFIN * PPRWGD;
        PRWGS_i = PRWGS + Inv_L * LPRWGS + Inv_NFIN * NPRWGS + Inv_LNFIN * PPRWGS;
        WR_i = WR + Inv_L * LWR + Inv_NFIN * NWR + Inv_LNFIN * PWR;
        PDIBL1_i = PDIBL1 + Inv_L * LPDIBL1 + Inv_NFIN * NPDIBL1 + Inv_LNFIN * PPDIBL1;
        PDIBL2_i = PDIBL2 + Inv_L * LPDIBL2 + Inv_NFIN * NPDIBL2 + Inv_LNFIN * PPDIBL2;
        DROUT_i = DROUT + Inv_L * LDROUT + Inv_NFIN * NDROUT + Inv_LNFIN * PDROUT;
        PVAG_i = PVAG + Inv_L * LPVAG + Inv_NFIN * NPVAG + Inv_LNFIN * PPVAG;
        AIGBINV_i = AIGBINV + Inv_L * LAIGBINV + Inv_NFIN * NAIGBINV + Inv_LNFIN * PAIGBINV;
        AIGBINV1_i = AIGBINV1 + Inv_L * LAIGBINV1 + Inv_NFIN * NAIGBINV1 + Inv_LNFIN * PAIGBINV1;
        BIGBINV_i = BIGBINV + Inv_L * LBIGBINV + Inv_NFIN * NBIGBINV + Inv_LNFIN * PBIGBINV;
        CIGBINV_i = CIGBINV + Inv_L * LCIGBINV + Inv_NFIN * NCIGBINV + Inv_LNFIN * PCIGBINV;
        EIGBINV_i = EIGBINV + Inv_L * LEIGBINV + Inv_NFIN * NEIGBINV + Inv_LNFIN * PEIGBINV;
        NIGBINV_i = NIGBINV + Inv_L * LNIGBINV + Inv_NFIN * NNIGBINV + Inv_LNFIN * PNIGBINV;
        AIGBACC_i = AIGBACC + Inv_L * LAIGBACC + Inv_NFIN * NAIGBACC + Inv_LNFIN * PAIGBACC;
        AIGBACC1_i = AIGBACC1 + Inv_L * LAIGBACC1 + Inv_NFIN * NAIGBACC1 + Inv_LNFIN * PAIGBACC1;
        BIGBACC_i = BIGBACC + Inv_L * LBIGBACC + Inv_NFIN * NBIGBACC + Inv_LNFIN * PBIGBACC;
        CIGBACC_i = CIGBACC + Inv_L * LCIGBACC + Inv_NFIN * NCIGBACC + Inv_LNFIN * PCIGBACC;
        NIGBACC_i = NIGBACC + Inv_L * LNIGBACC + Inv_NFIN * NNIGBACC + Inv_LNFIN * PNIGBACC;
        AIGC_i = AIGC + Inv_L * LAIGC + Inv_NFIN * NAIGC + Inv_LNFIN * PAIGC;
        AIGC1_i = AIGC1 + Inv_L * LAIGC1 + Inv_NFIN * NAIGC1 + Inv_LNFIN * PAIGC1;
        BIGC_i = BIGC + Inv_L * LBIGC + Inv_NFIN * NBIGC + Inv_LNFIN * PBIGC;
        CIGC_i = CIGC + Inv_L * LCIGC + Inv_NFIN * NCIGC + Inv_LNFIN * PCIGC;
        PIGCD_i = PIGCD + Inv_L * LPIGCD + Inv_NFIN * NPIGCD + Inv_LNFIN * PPIGCD;
        AIGS_i = AIGS + Inv_L * LAIGS + Inv_NFIN * NAIGS + Inv_LNFIN * PAIGS;
        AIGS1_i = AIGS1 + Inv_L * LAIGS1 + Inv_NFIN * NAIGS1 + Inv_LNFIN * PAIGS1;
        BIGS_i = BIGS + Inv_L * LBIGS + Inv_NFIN * NBIGS + Inv_LNFIN * PBIGS;
        CIGS_i = CIGS + Inv_L * LCIGS + Inv_NFIN * NCIGS + Inv_LNFIN * PCIGS;
        AIGD_i = AIGD + Inv_L * LAIGD + Inv_NFIN * NAIGD + Inv_LNFIN * PAIGD;
        AIGD1_i = AIGD1 + Inv_L * LAIGD1 + Inv_NFIN * NAIGD1 + Inv_LNFIN * PAIGD1;
        BIGD_i = BIGD + Inv_L * LBIGD + Inv_NFIN * NBIGD + Inv_LNFIN * PBIGD;
        CIGD_i = CIGD + Inv_L * LCIGD + Inv_NFIN * NCIGD + Inv_LNFIN * PCIGD;
        NTOX_i = NTOX + Inv_L * LNTOX + Inv_NFIN * NNTOX + Inv_LNFIN * PNTOX;
        POXEDGE_i = POXEDGE + Inv_L * LPOXEDGE + Inv_NFIN * NPOXEDGE + Inv_LNFIN * PPOXEDGE;
        AGIDL_i = AGIDL + Inv_L * LAGIDL + Inv_NFIN * NAGIDL + Inv_LNFIN * PAGIDL;
        BGIDL_i = BGIDL + Inv_L * LBGIDL + Inv_NFIN * NBGIDL + Inv_LNFIN * PBGIDL;
        CGIDL_i = CGIDL + Inv_L * LCGIDL + Inv_NFIN * NCGIDL + Inv_LNFIN * PCGIDL;
        EGIDL_i = EGIDL + Inv_L * LEGIDL + Inv_NFIN * NEGIDL + Inv_LNFIN * PEGIDL;
        PGIDL_i = PGIDL + Inv_L * LPGIDL + Inv_NFIN * NPGIDL + Inv_LNFIN * PPGIDL;
        AGISL_i = AGISL + Inv_L * LAGISL + Inv_NFIN * NAGISL + Inv_LNFIN * PAGISL;
        BGISL_i = BGISL + Inv_L * LBGISL + Inv_NFIN * NBGISL + Inv_LNFIN * PBGISL;
        CGISL_i = CGISL + Inv_L * LCGISL + Inv_NFIN * NCGISL + Inv_LNFIN * PCGISL;
        EGISL_i = EGISL + Inv_L * LEGISL + Inv_NFIN * NEGISL + Inv_LNFIN * PEGISL;
        PGISL_i = PGISL + Inv_L * LPGISL + Inv_NFIN * NPGISL + Inv_LNFIN * PPGISL;
        ALPHA0_i = ALPHA0 + Inv_L * LALPHA0 + Inv_NFIN * NALPHA0 + Inv_LNFIN * PALPHA0;
        ALPHA1_i = ALPHA1 + Inv_L * LALPHA1 + Inv_NFIN * NALPHA1 + Inv_LNFIN * PALPHA1;
        ALPHAII0_i = ALPHAII0 + Inv_L * LALPHAII0 + Inv_NFIN * NALPHAII0 + Inv_LNFIN * PALPHAII0;
        ALPHAII1_i = ALPHAII1 + Inv_L * LALPHAII1 + Inv_NFIN * NALPHAII1 + Inv_LNFIN * PALPHAII1;
        BETA0_i = BETA0 + Inv_L * LBETA0 + Inv_NFIN * NBETA0 + Inv_LNFIN * PBETA0;
        BETAII0_i = BETAII0 + Inv_L * LBETAII0 + Inv_NFIN * NBETAII0 + Inv_LNFIN * PBETAII0;
        BETAII1_i = BETAII1 + Inv_L * LBETAII1 + Inv_NFIN * NBETAII1 + Inv_LNFIN * PBETAII1;
        BETAII2_i = BETAII2 + Inv_L * LBETAII2 + Inv_NFIN * NBETAII2 + Inv_LNFIN * PBETAII2;
        ESATII_i = ESATII + Inv_L * LESATII + Inv_NFIN * NESATII + Inv_LNFIN * PESATII;
        LII_i = LII + Inv_L * LLII + Inv_NFIN * NLII + Inv_LNFIN * PLII;
        SII0_i = SII0 + Inv_L * LSII0 + Inv_NFIN * NSII0 + Inv_LNFIN * PSII0;
        SII1_i = SII1 + Inv_L * LSII1 + Inv_NFIN * NSII1 + Inv_LNFIN * PSII1;
        SII2_i = SII2 + Inv_L * LSII2 + Inv_NFIN * NSII2 + Inv_LNFIN * PSII2;
        SIID_i = SIID + Inv_L * LSIID + Inv_NFIN * NSIID + Inv_LNFIN * PSIID;
        TII_i = TII + Inv_L * LTII + Inv_NFIN * NTII + Inv_LNFIN * PTII;
        CFS_i = CFS + Inv_L * LCFS + Inv_NFIN * NCFS + Inv_LNFIN * PCFS;
        CFD_i = CFD + Inv_L * LCFD + Inv_NFIN * NCFD + Inv_LNFIN * PCFD;
        COVS_i = COVS + Inv_L * LCOVS + Inv_NFIN * NCOVS + Inv_LNFIN * PCOVS;
        COVD_i = COVD + Inv_L * LCOVD + Inv_NFIN * NCOVD + Inv_LNFIN * PCOVD;
        CGSL_i = CGSL + Inv_L * LCGSL + Inv_NFIN * NCGSL + Inv_LNFIN * PCGSL;
        CGDL_i = CGDL + Inv_L * LCGDL + Inv_NFIN * NCGDL + Inv_LNFIN * PCGDL;
        CGBL_i = CGBL + Inv_L * LCGBL + Inv_NFIN * NCGBL + Inv_LNFIN * PCGBL;
        CKAPPAS_i = CKAPPAS + Inv_L * LCKAPPAS + Inv_NFIN * NCKAPPAS + Inv_LNFIN * PCKAPPAS;
        CKAPPAD_i = CKAPPAD + Inv_L * LCKAPPAD + Inv_NFIN * NCKAPPAD + Inv_LNFIN * PCKAPPAD;
        CKAPPAB_i = CKAPPAB + Inv_L * LCKAPPAB + Inv_NFIN * NCKAPPAB + Inv_LNFIN * PCKAPPAB;
        NTGEN_i = NTGEN + Inv_L * LNTGEN + Inv_NFIN * NNTGEN + Inv_LNFIN * PNTGEN;
        AIGEN_i = AIGEN + Inv_L * LAIGEN + Inv_NFIN * NAIGEN + Inv_LNFIN * PAIGEN;
        BIGEN_i = BIGEN + Inv_L * LBIGEN + Inv_NFIN * NBIGEN + Inv_LNFIN * PBIGEN;
        if (ASYMMOD != 0) begin
            CDSCDR_i = CDSCDR + Inv_L * LCDSCDR + Inv_NFIN * NCDSCDR + Inv_LNFIN * PCDSCDR;
            CITR_i = CITR + Inv_L * LCITR + Inv_NFIN * NCITR + Inv_LNFIN * PCITR;
            ETA0R_i = ETA0R + Inv_L * LETA0R + Inv_NFIN * NETA0R + Inv_LNFIN * PETA0R;
            VSAT1R_i = VSAT1R + Inv_L * LVSAT1R + Inv_NFIN * NVSAT1R + Inv_LNFIN * PVSAT1R;
            MEXPR_i = MEXPR + Inv_L * LMEXPR + Inv_NFIN * NMEXPR + Inv_LNFIN * PMEXPR;
            PTWGR_i = PTWGR + Inv_L * LPTWGR + Inv_NFIN * NPTWGR + Inv_LNFIN * PPTWGR;
            PDIBL1R_i = PDIBL1R + Inv_L * LPDIBL1R + Inv_NFIN * NPDIBL1R + Inv_LNFIN * PPDIBL1R;
            PDIBL2R_i = PDIBL2R + Inv_L * LPDIBL2R + Inv_NFIN * NPDIBL2R + Inv_LNFIN * PPDIBL2R;
            PCLMR_i = PCLMR + Inv_L * LPCLMR + Inv_NFIN * NPCLMR + Inv_LNFIN * PPCLMR;
            DVTSHIFTR_i = DVTSHIFTR + Inv_L * LDVTSHIFTR + Inv_NFIN * NDVTSHIFTR + Inv_LNFIN * PDVTSHIFTR;
            VSATR_i = VSATR + Inv_L * LVSATR + Inv_NFIN * NVSATR + Inv_LNFIN * PVSATR;
            KSATIVR_i = KSATIVR + Inv_L * LKSATIVR + Inv_NFIN * NKSATIVR + Inv_LNFIN * PKSATIVR;
            U0R_i = U0R + Inv_L * LU0R + Inv_NFIN * NU0R + Inv_LNFIN * PU0R;
            UAR_i = UAR + Inv_L * LUAR + Inv_NFIN * NUAR + Inv_LNFIN * PUAR;
            UPR_i = UPR + Inv_L * LUPR + Inv_NFIN * NUPR + Inv_LNFIN * PUPR;
            if (BULKMOD != 0) begin
                UCR_i = UCR + Inv_L * LUCR + Inv_NFIN * NUCR + Inv_LNFIN * PUCR;
            end
            EUR_i = EUR + Inv_L * LEUR + Inv_NFIN * NEUR + Inv_LNFIN * PEUR;
            UDR_i = UDR + Inv_L * LUDR + Inv_NFIN * NUDR + Inv_LNFIN * PUDR;
        end
        if (NQSMOD == 1) begin
            $strobe(" Although the model selector NQSMOD is set to 1, the NQS gate resistance model is not activated in the Verilog-A code. Please uncomment \"`define __NQSMOD1__\" in bsimcmg.va to activate it.");
        end
        if (NQSMOD == 2) begin
            $strobe(" Although the model selector NQSMOD is set to 2, the NQS gate resistance model is not activated in the Verilog-A code. Please uncomment \"`define __NQSMOD2__\" in bsimcmg.va to activate it.");
        end
        UTE_i = UTE + Inv_L * LUTE + Inv_NFIN * NUTE + Inv_LNFIN * PUTE;
        UTL_i = UTL + Inv_L * LUTL + Inv_NFIN * NUTL + Inv_LNFIN * PUTL;
        EMOBT_i = EMOBT + Inv_L * LEMOBT + Inv_NFIN * NEMOBT + Inv_LNFIN * PEMOBT;
        UA1_i = UA1 + Inv_L * LUA1 + Inv_NFIN * NUA1 + Inv_LNFIN * PUA1;
        if (BULKMOD != 0) begin
            UC1_i = UC1 + Inv_L * LUC1 + Inv_NFIN * NUC1 + Inv_LNFIN * PUC1;
        end
        UD1_i = UD1 + Inv_L * LUD1 + Inv_NFIN * NUD1 + Inv_LNFIN * PUD1;
        UCSTE_i = UCSTE + Inv_L * LUCSTE + Inv_NFIN * NUCSTE + Inv_LNFIN * PUCSTE;
        PTWGT_i = PTWGT + Inv_L * LPTWGT + Inv_NFIN * NPTWGT + Inv_LNFIN * PPTWGT;
        AT_i = AT + Inv_L * LAT + Inv_NFIN * NAT + Inv_LNFIN * PAT;
        ATCV_i = ATCV + Inv_L * LATCV + Inv_NFIN * NATCV + Inv_LNFIN * PATCV;
        PRT_i = PRT + Inv_L * LPRT + Inv_NFIN * NPRT + Inv_LNFIN * PPRT;
        KT1_i = KT1 + Inv_L * LKT1 + Inv_NFIN * NKT1 + Inv_LNFIN * PKT1;
        TSS_i = TSS + Inv_L * LTSS + Inv_NFIN * NTSS + Inv_LNFIN * PTSS;
        IIT_i = IIT + Inv_L * LIIT + Inv_NFIN * NIIT + Inv_LNFIN * PIIT;
        TGIDL_i = TGIDL + Inv_L * LTGIDL + Inv_NFIN * NTGIDL + Inv_LNFIN * PTGIDL;
        IGT_i = IGT + Inv_L * LIGT + Inv_NFIN * NIGT + Inv_LNFIN * PIGT;
        if (ASYMMOD != 0) begin
            UTER_i = UTER + Inv_L * LUTER + Inv_NFIN * NUTER + Inv_LNFIN * PUTER;
            UTLR_i = UTLR + Inv_L * LUTLR + Inv_NFIN * NUTLR + Inv_LNFIN * PUTLR;
            UA1R_i = UA1R + Inv_L * LUA1R + Inv_NFIN * NUA1R + Inv_LNFIN * PUA1R;
            UD1R_i = UD1R + Inv_L * LUD1R + Inv_NFIN * NUD1R + Inv_LNFIN * PUD1R;
            ATR_i = ATR + Inv_L * LATR + Inv_NFIN * NATR + Inv_LNFIN * PATR;
            if (BULKMOD != 0) begin
                UC1R_i = UC1R + Inv_L * LUC1R + Inv_NFIN * NUC1R + Inv_LNFIN * PUC1R;
            end
        end
        if (PHIGN1 != 0.0) begin
            _argR4_1_ = 1.0 + NFIN / PHIGN2;
            begin : llnE04
                real lln;
                real x_f2;

                x_f2 = _argR4_1_;
                lln = ln(max(x_f2,9.9999999999999996e-39));
                llnE04 = lln;
            end
            PHIG_i = PHIG_i * (1.0 + PHIGN1 / NFIN * llnE04);
        end
        if (ETA0N1 != 0.0) begin
            _argR5_1_ = 1.0 + NFIN / ETA0N2;
            begin : llnE05
                real lln;
                real x_f2;

                x_f2 = _argR5_1_;
                lln = ln(max(x_f2,9.9999999999999996e-39));
                llnE05 = lln;
            end
            ETA0_i = ETA0_i * (1.0 + ETA0N1 / NFIN * llnE05);
        end
        if (CDSCN1 != 0.0) begin
            _argR6_1_ = 1.0 + NFIN / CDSCN2;
            begin : llnE06
                real lln;
                real x_f2;

                x_f2 = _argR6_1_;
                lln = ln(max(x_f2,9.9999999999999996e-39));
                llnE06 = lln;
            end
            CDSC_i = CDSC_i * (1.0 + CDSCN1 / NFIN * llnE06);
        end
        if (CDSCDN1 != 0.0) begin
            _argR7_1_ = 1.0 + NFIN / CDSCDN2;
            begin : llnE07
                real lln;
                real x_f2;

                x_f2 = _argR7_1_;
                lln = ln(max(x_f2,9.9999999999999996e-39));
                llnE07 = lln;
            end
            CDSCD_i = CDSCD_i * (1.0 + CDSCDN1 / NFIN * llnE07);
        end
        if (CDSCDRN1 != 0.0) begin
            _argR8_1_ = 1.0 + NFIN / CDSCDRN2;
            begin : llnE08
                real lln;
                real x_f2;

                x_f2 = _argR8_1_;
                lln = ln(max(x_f2,9.9999999999999996e-39));
                llnE08 = lln;
            end
            CDSCDR_i = CDSCDR_i * (1.0 + CDSCDRN1 / NFIN * llnE08);
        end
        if (VSATN1 != 0.0) begin
            _argR9_1_ = 1.0 + NFIN / VSATN2;
            begin : llnE09
                real lln;
                real x_f2;

                x_f2 = _argR9_1_;
                lln = ln(max(x_f2,9.9999999999999996e-39));
                llnE09 = lln;
            end
            VSAT_i = VSAT_i * (1.0 + VSATN1 / NFIN * llnE09);
        end
        if (VSAT1N1 != 0.0) begin
            _argR10_1_ = 1.0 + NFIN / VSAT1N2;
            begin : llnE10
                real lln;
                real x_f2;

                x_f2 = _argR10_1_;
                lln = ln(max(x_f2,9.9999999999999996e-39));
                llnE10 = lln;
            end
            VSAT1_i = VSAT1_i * (1.0 + VSAT1N1 / NFIN * llnE10);
        end
        if (VSAT1RN1 != 0.0) begin
            _argR11_1_ = 1.0 + NFIN / VSAT1RN2;
            begin : llnE11
                real lln;
                real x_f2;

                x_f2 = _argR11_1_;
                lln = ln(max(x_f2,9.9999999999999996e-39));
                llnE11 = lln;
            end
            VSAT1R_i = VSAT1R_i * (1.0 + VSAT1RN1 / NFIN * llnE11);
        end
        if (U0N1 != 0.0) begin
            _argR12_1_ = 1.0 + NFIN / U0N2;
            begin : llnE12
                real lln;
                real x_f2;

                x_f2 = _argR12_1_;
                lln = ln(max(x_f2,9.9999999999999996e-39));
                llnE12 = lln;
            end
            U0_i = U0_i * (1.0 + U0N1 / NFIN * llnE12);
        end
        if ($param_given(NFINNOM)) begin
            PHIG_i = PHIG_i * (1.0 + (NFIN - NFINNOM) * PHIGLT * Leff);
            ETA0_i = ETA0_i * (1.0 + (NFIN - NFINNOM) * ETA0LT * Leff);
            U0_i = U0_i * (1.0 + (NFIN - NFINNOM) * U0LT * Leff);
        end
        if (U0N1R != 0.0) begin
            _argR13_1_ = 1.0 + NFIN / U0N2R;
            begin : llnE13
                real lln;
                real x_f2;

                x_f2 = _argR13_1_;
                lln = ln(max(x_f2,9.9999999999999996e-39));
                llnE13 = lln;
            end
            U0R_i = U0R_i * (1.0 + U0N1R / NFIN * llnE13);
        end
        PHIG_i = PHIG_i + PHIGL * Leff;
        if (LPA > 0.0) begin
            U0_i = U0_i * (1.0 - UP_i * pow(Leff,-LPA));
        end
        else begin
            U0_i = U0_i * (1.0 - UP_i);
        end
        _argR14_1_ = -Leff / BUA;
        begin : lexpE14
            real lexp;
            real x_f1;

            x_f1 = _argR14_1_;
            if (x_f1 > 80.0) begin
                lexp = 5.540622384000e+34 * (1.0 + x_f1 - 80.0);
            end
            else if (x_f1 < -80.0) begin
                lexp = 1.804851387e-35;
            end
            else begin
                lexp = exp(x_f1);
            end
            lexpE14 = lexp;
        end
        UA_i = UA_i + AUA * lexpE14;
        _argR15_1_ = -Leff / BUD;
        begin : lexpE15
            real lexp;
            real x_f1;

            x_f1 = _argR15_1_;
            if (x_f1 > 80.0) begin
                lexp = 5.540622384000e+34 * (1.0 + x_f1 - 80.0);
            end
            else if (x_f1 < -80.0) begin
                lexp = 1.804851387e-35;
            end
            else begin
                lexp = exp(x_f1);
            end
            lexpE15 = lexp;
        end
        UD_i = UD_i + AUD * lexpE15;
        _argR16_1_ = -Leff / BEU;
        begin : lexpE16
            real lexp;
            real x_f1;

            x_f1 = _argR16_1_;
            if (x_f1 > 80.0) begin
                lexp = 5.540622384000e+34 * (1.0 + x_f1 - 80.0);
            end
            else if (x_f1 < -80.0) begin
                lexp = 1.804851387e-35;
            end
            else begin
                lexp = exp(x_f1);
            end
            lexpE16 = lexp;
        end
        EU_i = EU_i + AEU * lexpE16;
        if (ASYMMOD != 0) begin
            if (LPAR > 0.0) begin
                U0R_i = U0R_i * (1.0 - UPR_i * pow(Leff,-LPAR));
            end
            else begin
                U0R_i = U0R_i * (1.0 - UPR_i);
            end
            _argR17_1_ = -Leff / BUAR;
            begin : lexpE17
                real lexp;
                real x_f1;

                x_f1 = _argR17_1_;
                if (x_f1 > 80.0) begin
                    lexp = 5.540622384000e+34 * (1.0 + x_f1 - 80.0);
                end
                else if (x_f1 < -80.0) begin
                    lexp = 1.804851387e-35;
                end
                else begin
                    lexp = exp(x_f1);
                end
                lexpE17 = lexp;
            end
            UAR_i = UAR_i + AUAR * lexpE17;
            _argR18_1_ = -Leff / BUDR;
            begin : lexpE18
                real lexp;
                real x_f1;

                x_f1 = _argR18_1_;
                if (x_f1 > 80.0) begin
                    lexp = 5.540622384000e+34 * (1.0 + x_f1 - 80.0);
                end
                else if (x_f1 < -80.0) begin
                    lexp = 1.804851387e-35;
                end
                else begin
                    lexp = exp(x_f1);
                end
                lexpE18 = lexp;
            end
            UDR_i = UDR_i + AUDR * lexpE18;
            _argR19_1_ = -Leff / BEUR;
            begin : lexpE19
                real lexp;
                real x_f1;

                x_f1 = _argR19_1_;
                if (x_f1 > 80.0) begin
                    lexp = 5.540622384000e+34 * (1.0 + x_f1 - 80.0);
                end
                else if (x_f1 < -80.0) begin
                    lexp = 1.804851387e-35;
                end
                else begin
                    lexp = exp(x_f1);
                end
                lexpE19 = lexp;
            end
            EUR_i = EUR_i + AEUR * lexpE19;
        end
        if (RDSMOD == 1) begin
            _argR20_1_ = -Leff / BRSW;
            begin : lexpE20
                real lexp;
                real x_f1;

                x_f1 = _argR20_1_;
                if (x_f1 > 80.0) begin
                    lexp = 5.540622384000e+34 * (1.0 + x_f1 - 80.0);
                end
                else if (x_f1 < -80.0) begin
                    lexp = 1.804851387e-35;
                end
                else begin
                    lexp = exp(x_f1);
                end
                lexpE20 = lexp;
            end
            RSW_i = RSW_i + ARSW * lexpE20;
            _argR21_1_ = -Leff / BRDW;
            begin : lexpE21
                real lexp;
                real x_f1;

                x_f1 = _argR21_1_;
                if (x_f1 > 80.0) begin
                    lexp = 5.540622384000e+34 * (1.0 + x_f1 - 80.0);
                end
                else if (x_f1 < -80.0) begin
                    lexp = 1.804851387e-35;
                end
                else begin
                    lexp = exp(x_f1);
                end
                lexpE21 = lexp;
            end
            RDW_i = RDW_i + ARDW * lexpE21;
        end
        else begin
            _argR22_1_ = -Leff / BRDSW;
            begin : lexpE22
                real lexp;
                real x_f1;

                x_f1 = _argR22_1_;
                if (x_f1 > 80.0) begin
                    lexp = 5.540622384000e+34 * (1.0 + x_f1 - 80.0);
                end
                else if (x_f1 < -80.0) begin
                    lexp = 1.804851387e-35;
                end
                else begin
                    lexp = exp(x_f1);
                end
                lexpE22 = lexp;
            end
            RDSW_i = RDSW_i + ARDSW * lexpE22;
        end
        _argR23_1_ = -Leff / BPCLM;
        begin : lexpE23
            real lexp;
            real x_f1;

            x_f1 = _argR23_1_;
            if (x_f1 > 80.0) begin
                lexp = 5.540622384000e+34 * (1.0 + x_f1 - 80.0);
            end
            else if (x_f1 < -80.0) begin
                lexp = 1.804851387e-35;
            end
            else begin
                lexp = exp(x_f1);
            end
            lexpE23 = lexp;
        end
        PCLM_i = PCLM_i + APCLM * lexpE23;
        if (ASYMMOD != 0) begin
            PCLMR_i = PCLMR_i + APCLMR * pow(Leff,-BPCLMR);
        end
        MEXP_i = MEXP_i + AMEXP * pow(Leff,-BMEXP);
        if (ASYMMOD != 0) begin
            MEXPR_i = MEXPR_i + AMEXPR * pow(Leff,-BMEXPR);
        end
        _argR24_1_ = -Leff / BPTWG;
        begin : lexpE24
            real lexp;
            real x_f1;

            x_f1 = _argR24_1_;
            if (x_f1 > 80.0) begin
                lexp = 5.540622384000e+34 * (1.0 + x_f1 - 80.0);
            end
            else if (x_f1 < -80.0) begin
                lexp = 1.804851387e-35;
            end
            else begin
                lexp = exp(x_f1);
            end
            lexpE24 = lexp;
        end
        PTWG_i = PTWG_i + APTWG * lexpE24;
        if (ASYMMOD != 0) begin
            _argR25_1_ = -Leff / BPTWG;
            begin : lexpE25
                real lexp;
                real x_f1;

                x_f1 = _argR25_1_;
                if (x_f1 > 80.0) begin
                    lexp = 5.540622384000e+34 * (1.0 + x_f1 - 80.0);
                end
                else if (x_f1 < -80.0) begin
                    lexp = 1.804851387e-35;
                end
                else begin
                    lexp = exp(x_f1);
                end
                lexpE25 = lexp;
            end
            PTWGR_i = PTWGR_i + APTWG * lexpE25;
        end
        _argR26_1_ = -Leff / BVSAT;
        begin : lexpE26
            real lexp;
            real x_f1;

            x_f1 = _argR26_1_;
            if (x_f1 > 80.0) begin
                lexp = 5.540622384000e+34 * (1.0 + x_f1 - 80.0);
            end
            else if (x_f1 < -80.0) begin
                lexp = 1.804851387e-35;
            end
            else begin
                lexp = exp(x_f1);
            end
            lexpE26 = lexp;
        end
        VSAT_i = VSAT_i + AVSAT * lexpE26;
        _argR27_1_ = -Leff / BVSAT1;
        begin : lexpE27
            real lexp;
            real x_f1;

            x_f1 = _argR27_1_;
            if (x_f1 > 80.0) begin
                lexp = 5.540622384000e+34 * (1.0 + x_f1 - 80.0);
            end
            else if (x_f1 < -80.0) begin
                lexp = 1.804851387e-35;
            end
            else begin
                lexp = exp(x_f1);
            end
            lexpE27 = lexp;
        end
        VSAT1_i = VSAT1_i + AVSAT1 * lexpE27;
        if (ASYMMOD != 0) begin
            _argR28_1_ = -Leff / BVSAT1;
            begin : lexpE28
                real lexp;
                real x_f1;

                x_f1 = _argR28_1_;
                if (x_f1 > 80.0) begin
                    lexp = 5.540622384000e+34 * (1.0 + x_f1 - 80.0);
                end
                else if (x_f1 < -80.0) begin
                    lexp = 1.804851387e-35;
                end
                else begin
                    lexp = exp(x_f1);
                end
                lexpE28 = lexp;
            end
            VSAT1R_i = VSAT1R_i + AVSAT1 * lexpE28;
        end
        _argR29_1_ = -Leff / BPSAT;
        begin : lexpE29
            real lexp;
            real x_f1;

            x_f1 = _argR29_1_;
            if (x_f1 > 80.0) begin
                lexp = 5.540622384000e+34 * (1.0 + x_f1 - 80.0);
            end
            else if (x_f1 < -80.0) begin
                lexp = 1.804851387e-35;
            end
            else begin
                lexp = exp(x_f1);
            end
            lexpE29 = lexp;
        end
        PSAT_i = PSAT_i + APSAT * lexpE29;
        _argR30_1_ = -Leff / BPSATCV;
        begin : lexpE30
            real lexp;
            real x_f1;

            x_f1 = _argR30_1_;
            if (x_f1 > 80.0) begin
                lexp = 5.540622384000e+34 * (1.0 + x_f1 - 80.0);
            end
            else if (x_f1 < -80.0) begin
                lexp = 1.804851387e-35;
            end
            else begin
                lexp = exp(x_f1);
            end
            lexpE30 = lexp;
        end
        PSATCV_i = PSATCV_i + APSATCV * lexpE30;
        _argR31_1_ = -LeffCV / BVSATCV;
        begin : lexpE31
            real lexp;
            real x_f1;

            x_f1 = _argR31_1_;
            if (x_f1 > 80.0) begin
                lexp = 5.540622384000e+34 * (1.0 + x_f1 - 80.0);
            end
            else if (x_f1 < -80.0) begin
                lexp = 1.804851387e-35;
            end
            else begin
                lexp = exp(x_f1);
            end
            lexpE31 = lexp;
        end
        VSATCV_i = VSATCV_i + AVSATCV * lexpE31;
        _argR32_1_ = -Leff / BDVTP0;
        begin : lexpE32
            real lexp;
            real x_f1;

            x_f1 = _argR32_1_;
            if (x_f1 > 80.0) begin
                lexp = 5.540622384000e+34 * (1.0 + x_f1 - 80.0);
            end
            else if (x_f1 < -80.0) begin
                lexp = 1.804851387e-35;
            end
            else begin
                lexp = exp(x_f1);
            end
            lexpE32 = lexp;
        end
        DVTP0_i = DVTP0 + ADVTP0 * lexpE32;
        _argR33_1_ = -Leff / BDVTP1;
        begin : lexpE33
            real lexp;
            real x_f1;

            x_f1 = _argR33_1_;
            if (x_f1 > 80.0) begin
                lexp = 5.540622384000e+34 * (1.0 + x_f1 - 80.0);
            end
            else if (x_f1 < -80.0) begin
                lexp = 1.804851387e-35;
            end
            else begin
                lexp = exp(x_f1);
            end
            lexpE33 = lexp;
        end
        DVTP1_i = DVTP1 + ADVTP1 * lexpE33;
        if (QMTCENCV_i > 0.0 || QMTCENCVA_i > 0.0) begin
            _argR34_1_ = -(2.0 * Ach / Weff_UFCM) / BQMTCEN;
            begin : lexpE34
                real lexp;
                real x_f1;

                x_f1 = _argR34_1_;
                if (x_f1 > 80.0) begin
                    lexp = 5.540622384000e+34 * (1.0 + x_f1 - 80.0);
                end
                else if (x_f1 < -80.0) begin
                    lexp = 1.804851387e-35;
                end
                else begin
                    lexp = exp(x_f1);
                end
                lexpE34 = lexp;
            end
            MTcen = 1.0 + AQMTCEN * lexpE34;
            Tcen0 = (2.0 * Ach / Weff_UFCM) * MTcen;
        end
        if (LeffCV <= 1e-09) begin
            $strobe("Warning: LeffCV = %e <= 1.0e-9.",LeffCV);
        end
        if (BULKMOD != 0) begin
            if (LeffCV_acc <= 1e-09) begin
                $strobe("Warning: LeffCV_acc = %e <= 1.0e-9.",LeffCV_acc);
            end
        end
        if (Weff0 <= 1e-09) begin
            $strobe("Warning: Weff0 = %e <= 1.0e-9.",Weff0);
        end
        if (WeffCV0 <= 1e-09) begin
            $strobe("Warning: WeffCV0 = %e <= 1.0e-9.",WeffCV0);
        end
        if (NBODY_i <= 0.0) begin
            $strobe("Fatal: NBODY_i = %e is not positive.",NBODY_i);
            $finish(0);
        end
        else if (NBODY_i < 1.000000000000e+18) begin
            $strobe("Warning: NBODY_i = %e m^-3 may be too small.",NBODY_i);
        end
        if (NGATE_i < 0.0) begin
            $strobe("Fatal: NGATE_i = %e is negative.",NGATE_i);
            $finish(0);
        end
        else if (NGATE_i != 0.0 && NGATE_i <= 1.000000000000e+24) begin
            $strobe("Warning: NGATE_i = %e may be too small.",NGATE_i);
        end
        else if (NGATE_i > 1.000000000000e+31) begin
            $strobe("Fatal: NGATE_i = %e is too high.",NGATE_i);
            $finish(0);
        end
        if (DVT0_i < 0.0) begin
            $strobe("Warning: DVT0_i = %e is negative.",DVT0_i);
        end
        if (PHIG_i <= 0.0) begin
            $strobe("Fatal: PHIG_i = %e is not positive.",PHIG_i);
            $finish(0);
        end
        if (VSAT_i <= 0.0) begin
            $strobe("Fatal: VSAT_i = %e is not positive.",VSAT_i);
            $finish(0);
        end
        if (VSAT1_i <= 0.0) begin
            $strobe("Fatal: VSAT1_i = %e is not positive.",VSAT1_i);
            $finish(0);
        end
        if (ASYMMOD != 0 && VSAT1R_i <= 0.0) begin
            $strobe("Fatal: VSAT1R_i = %e is not positive.",VSAT1R_i);
            $finish(0);
        end
        if (DVT1_i <= 0.0) begin
            $strobe("Fatal: DVT1_i = %e is not positive.",DVT1_i);
            $finish(0);
        end
        if (DVT1SS_i <= 0.0) begin
            $strobe("Fatal: DVT1SS_i = %e is not positive.",DVT1SS_i);
            $finish(0);
        end
        if (CDSC_i < 0.0) begin
            $strobe("Warning: CDSC_i = %e is negative.",CDSC_i);
        end
        if (CDSCD_i < 0.0) begin
            $strobe("Warning: CDSCD_i = %e is negative.",CDSCD_i);
        end
        if (ASYMMOD != 0 && CDSCDR_i < 0.0) begin
            $strobe("Warning: CDSCDR_i = %e is negative.",CDSCDR_i);
        end
        if (DSUB_i <= 0.0) begin
            $strobe("Fatal: DSUB_i = %e is not positive.",DSUB_i);
            $finish(0);
        end
        if (ETA0_i < 0.0) begin
            $strobe("Warning: ETA0_i = %e is negative, setting it to 0",ETA0_i);
            ETA0_i = 0.0;
        end
        if (ETA0R_i < 0.0) begin
            $strobe("Warning: ETA0R_i = %e is negative, setting it to 0",ETA0R_i);
            ETA0R_i = 0.0;
        end
        if (LPE0_i < -Leff) begin
            $strobe("Warning: LPE0_i = %e is less than -Leff. Clipping LPE0_i to 0",LPE0_i);
            LPE0_i = 0.0;
        end
        if (K0SI_i <= 0.0) begin
            $strobe("Warning: K0SI_i = %e is not positive, setting it to 0.",K0SI_i);
            K0SI_i = 0.0;
        end
        if (K2SI_i <= 0.0) begin
            $strobe("Warning: K2SI_i = %e is not positive, setting it to 0.",K2SI_i);
            K2SI_i = 0.0;
        end
        if (PHIBE_i < 0.2 && BULKMOD != 0) begin
            $strobe("Warning: PHIBE_i = %e is less than 0.2, setting it to 0.2.",PHIBE_i);
            PHIBE_i = 0.2;
        end
        if (PHIBE_i > 1.2 && BULKMOD != 0) begin
            $strobe("Warning: PHIBE_i = %e is larger than 1.2, setting it to 1.2.",PHIBE_i);
            PHIBE_i = 1.2;
        end
        if (PSAT_i < 2.0) begin
            $strobe("Warning: PSAT_i = %e is less than 2.0, setting it to 2.0.",PSAT_i);
            PSAT_i = 2.0;
        end
        if (PSATCV_i < 2.0) begin
            $strobe("Warning: PSATCV_i = %e is less than 2.0, setting it to 2.0.",PSATCV_i);
            PSATCV_i = 2.0;
        end
        if (U0_i < 0.0) begin
            $strobe("Warning: U0_i = %e is negative, setting it to the default value.",U0_i);
            U0_i = 0.03;
        end
        if (UA_i < 0.0) begin
            $strobe("Warning: UA_i = %e is negative, setting it to 0.",UA_i);
            UA_i = 0.0;
        end
        if (EU_i < 0.0) begin
            $strobe("Warning: EU_i = %e is negative, setting it to 0.",EU_i);
            EU_i = 0.0;
        end
        if (UD_i < 0.0) begin
            $strobe("Warning: UD_i = %e is negative, setting it to 0.",UD_i);
            UD_i = 0.0;
        end
        if (UCS_i < 0.0) begin
            $strobe("Warning: UCS_i = %e is negative, setting it to 0.",UCS_i);
            UCS_i = 0.0;
        end
        if (ETAMOB_i < 0.0) begin
            $strobe("Warning: ETAMOB_i = %e is negative, setting it to 0",ETAMOB_i);
            ETAMOB_i = 0.0;
        end
        RDSWMIN_i = RDSWMIN;
        if (RDSWMIN_i < 0.0) begin
            $strobe("Warning: RDSWMIN = %e is negative.  Set to zero",RDSWMIN_i);
            RDSWMIN_i = 0.0;
        end
        if (RDSW_i < 0.0) begin
            $strobe("Warning: RDSW_i = %e is negative.  Set to zero",RDSW_i);
            RDSW_i = 0.0;
        end
        RSWMIN_i = RSWMIN;
        if (RSWMIN_i < 0.0) begin
            $strobe("Warning: RSWMIN = %e is negative.  Set to zero",RSWMIN_i);
            RSWMIN_i = 0.0;
        end
        if (RSW_i < 0.0) begin
            $strobe("Warning: RSW_i = %e is negative.  Set to zero",RSW_i);
            RSW_i = 0.0;
        end
        RDWMIN_i = RDWMIN;
        if (RDWMIN_i < 0.0) begin
            $strobe("Warning: RDWMIN = %e is negative.  Set to zero",RDWMIN_i);
            RDWMIN_i = 0.0;
        end
        if (RDW_i < 0) begin
            $strobe("Warning: RDW_i = %e is negative.  Set to zero",RDW_i);
            RDW_i = 0.0;
        end
        if (PRWGD_i < 0.0) begin
            $strobe("Warning: PRWGD_i = %e is negative.  Set to zero",PRWGD_i);
            PRWGD_i = 0.0;
        end
        if (PRWGS_i < 0.0) begin
            $strobe("Warning: PRWGS_i = %e is negative.  Set to zero",PRWGS_i);
            PRWGS_i = 0.0;
        end
        if (PCLM_i < 0) begin
            $strobe("Warning: PCLM_i = %e is negative.",PCLM_i);
        end
        if (PDIBL1_i < 0.0) begin
            $strobe("Warning: PDIBL1_i = %e is negative.",PDIBL1_i);
        end
        if (ASYMMOD != 0) begin
            if (PDIBL1R_i < 0.0) begin
                $strobe("Warning: PDIBL1R_i = %e is negative.",PDIBL1R_i);
            end
            if (PDIBL2R_i < 0.0) begin
                $strobe("Warning: PDIBL2R_i = %e is negative.",PDIBL2R_i);
            end
            if (U0R_i < 0) begin
                $strobe("Warning: U0R_i = %e is negative, setting it to 0.",U0R_i);
                U0R_i = 0.0;
            end
            if (UAR_i < 0.0) begin
                $strobe("Warning: UAR_i = %e is negative, setting it to 0.",UAR_i);
                UAR_i = 0.0;
            end
            if (EUR_i < 0.0) begin
                $strobe("Warning: EUR_i = %e is negative, setting it to 0.",EUR_i);
                EUR_i = 0.0;
            end
            if (UDR_i < 0.0) begin
                $strobe("Warning: UDR_i = %e is negative, setting it to 0.",UDR_i);
                UDR_i = 0.0;
            end
        end
        if (PDIBL2_i < 0.0) begin
            $strobe("Warning: PDIBL2_i = %e is negative.",PDIBL2_i);
        end
        if (DROUT_i <= 0.0) begin
            $strobe("Fatal: DROUT_i = %e is non-positive.",DROUT_i);
            $finish(0);
        end
        if (MEXP_i < 2.0) begin
            $strobe("Warning: MEXP_i = %e < 2. Setting MEXP_i = 2.",MEXP_i);
            MEXP_i = 2.0;
        end
        if (ASYMMOD != 0) begin
            if (MEXPR_i < 2.0) begin
                $strobe("Warning: MEXPR_i = %e < 2.  Setting MEXPR_i = 2.",MEXPR_i);
                MEXPR_i = 2.0;
            end
        end
        if (PTWG_i < 0) begin
            $strobe("Warning: PTWG_i = %e is negative, setting it to 0.",PTWG_i);
            PTWG_i = 0.0;
        end
        if (QMTCENCV_i > 0.0) begin
            if (QM0 <= 0.0) begin
                $strobe("Fatal: QM0 = %e is non-positive.",QM0);
                $finish(0);
            end
        end
        if (BULKMOD != 0 && QMTCENCVA_i > 0.0) begin
            if (QM0ACC <= 0.0) begin
                $strobe("Fatal: QM0ACC = %e is non-positive.",QM0ACC);
                $finish(0);
            end
        end
        if (CGIDL_i < 0.0) begin
            $strobe("Warning: CGIDL_i = %e < 0.  Setting CGIDL_i = 0.",CGIDL_i);
            CGIDL_i = 0.0;
        end
        if (CGISL_i < 0.0) begin
            $strobe("Warning: CGISL_i = %e < 0.  Setting CGISL_i = 0.",CGISL_i);
            CGISL_i = 0.0;
        end
        if (IGBMOD != 0) begin
            if (NIGBINV_i <= 0.0) begin
                $strobe("Fatal: NIGBINV_i = %e is non-positive.",NIGBINV_i);
                $finish(0);
            end
            if (NIGBACC_i <= 0.0) begin
                $strobe("Fatal: NIGBACC_i = %e is non-positive.",NIGBACC_i);
                $finish(0);
            end
        end
        if (IGCMOD != 0) begin
            if (POXEDGE_i <= 0.0) begin
                $strobe("Fatal: POXEDGE_i = %e is non-positive.",POXEDGE_i);
                $finish(0);
            end
            if (PIGCD_i <= 0.0) begin
                $strobe("Fatal: PIGCD_i = %e is non-positive.",PIGCD_i);
                $finish(0);
            end
        end
        if (IGCMOD != 0 || IGBMOD != 0) begin
            if (TOXREF <= 0) begin
                $strobe("Fatal: TOXREF = %e is non-positive.",TOXREF);
                $finish(0);
            end
        end
        if (LINTIGEN >= (Leff / 2.0)) begin
            $strobe("Warning: LINTIGEN = %e is too large - Leff for r/g current is negative.  Re-setting LINTIGEN = 0.",LINTIGEN);
            LINTIGEN_i = 0.0;
        end
        else begin
            LINTIGEN_i = LINTIGEN;
        end
        if (NTGEN_i <= 0.0) begin
            $strobe("Fatal: NTGEN_i = %e is non-positive.",NTGEN_i);
            $finish(0);
        end
        if (IIMOD == 2) begin
            if (BETAII0_i < 0.0) begin
                $strobe("Warning:  BETAII0_i = %e is negative.",BETAII0_i);
            end
            if (BETAII1_i < 0.0) begin
                $strobe("Warning:  BETAII1_i = %e is negative.",BETAII1_i);
            end
            if (BETAII2_i < 0.0) begin
                $strobe("Warning:  BETAII2_i = %e is negative.",BETAII2_i);
            end
            if (ESATII_i < 0.0) begin
                $strobe("Warning:  ESATII_i = %e is negative.",ESATII_i);
            end
            if (LII_i < 0.0) begin
                $strobe("Warning:  LII_i = %e is negative.",LII_i);
            end
            if (SII1_i < 0.0) begin
                $strobe("Warning:  SII1_i = %e is negative.",SII1);
            end
            if (SII2_i < 0.0) begin
                $strobe("Warning:  SII2_i = %e is negative.",SII2_i);
            end
            if (SIID_i < 0.0) begin
                $strobe("Warning:  SIID_i = %e is negative.",SIID_i);
            end
        end
        if (EF <= 0.0) begin
            $strobe("Fatal: EF = %e is non-positive.",EF);
            $finish(0);
        end
        else if (EF > 2.0) begin
            $strobe("Fatal: EF = %e > 2.0.",EF);
            $finish(0);
        end
        if (LINTNOI >= (Leff / 2.0)) begin
            $strobe("Warning: LINTNOI = %e is too large - Leff for noise is negative.  Re-setting LINTNOI = 0.",LINTNOI);
            LINTNOI_i = 0.0;
        end
        else begin
            LINTNOI_i = LINTNOI;
        end
        if (NTNOI < 0) begin
            $strobe("Warning: NTNOI = %e is negative. Set to zero.",NTNOI);
            NTNOI_i = 0.0;
        end
        else begin
            NTNOI_i = NTNOI;
        end
        if (SHMOD != 0 && RTH0 > 0.0) begin
            T1 = WTH0;
            if (BSHEXP != 0.0) begin
                T1 = WTH0 * pow(NF,BSHEXP);
            end
            T2 = FPITCH;
            if (ASHEXP != 0.0) begin
                T2 = FPITCH * pow(NFINtotal,ASHEXP);
            end
            gth = (T1 + T2) / RTH0;
            cth = CTH0 * (T1 + T2);
        end
        else begin
            gth = 1.0;
            cth = 0.0;
        end
        if (RGATEMOD != 0) begin
            Rgeltd = (RGEXT / NGCON + (RGFIN * NFIN) / ((NGCON == 2)?12.0:3.0)) / NF;
            ggeltd = 1.0 / max(0.001,Rgeltd);
        end
        if (RGEOMOD == 0) begin
            RSourceGeo = RSHS * NRS;
            RDrainGeo = RSHD * NRD;
        end
        else begin
            if (HEPI > 0.0) begin
                Arsd = 2.0 * (TFIN + (FPITCH - TFIN) * CRATIO) * HEPI;
            end
            else begin
                Arsd = FPITCH * max(1e-09,HFIN + HEPI);
            end
            Prsd = FPITCH + DELTAPRSD;
            if ($param_given(RHORSD)) begin
                rhorsd = RHORSD;
            end
            else begin
                mu_max = ((TYPE == 1))?1417.0:470.5;
                if (TYPE == 1) begin
                    mu_rsd = (52.2 + (mu_max - 52.2) / (1.0 + pow(NSD / 9.680000000000e+22,0.68)) - 43.4 / (1.0 + pow(3.430000000000e+26 / NSD,2.0))) * 0.0001;
                end
                else begin
                    mu_rsd = (44.9 + (mu_max - 44.9) / (1.0 + pow(NSD / 2.230000000000e+22,0.719)) - 29.0 / (1.0 + pow(6.100000000000e+26 / NSD,2.0))) * 0.0001;
                end
                rhorsd = 1.0 / (1.6021899999999999e-19 * NSD * mu_rsd);
            end
            thetarsp = 55.0 * 3.141592653589793 / 180.0;
            afin = min(Arsd,max(1.0000000000000001e-18,TFIN * (HFIN + min(0.0,HEPI))));
            T1 = (((thetarsp) >= 3.141592653589793 / 2)?0:(((thetarsp) <= -3.141592653589793 / 2)?0:1.0 / tan(thetarsp)));
            Rsp = rhorsd * T1 / (sqrt(3.141592653589793) * NFIN) * (1.0 / sqrt(afin) - 2.0 / sqrt(Arsd) + sqrt(afin / (Arsd * Arsd)));
            arsd_total = Arsd * NFIN + ARSDEND;
            prsd_total = Prsd * NFIN + PRSDEND;
            lt = sqrt(RHOC * arsd_total / (rhorsd * prsd_total));
            alpha = LRSD / lt;
            _argR35_1_ = alpha + alpha;
            begin : lexpE35
                real lexp;
                real x_f1;

                x_f1 = _argR35_1_;
                if (x_f1 > 80.0) begin
                    lexp = 5.540622384000e+34 * (1.0 + x_f1 - 80.0);
                end
                else if (x_f1 < -80.0) begin
                    lexp = 1.804851387e-35;
                end
                else begin
                    lexp = exp(x_f1);
                end
                lexpE35 = lexp;
            end
            T0 = lexpE35;
            if (SDTERM == 1.0) begin
                eta = rhorsd * lt / RHOC;
                T1 = T0 * (1.0 + eta);
                T2 = T1 + 1.0 - eta;
                T3 = T1 - 1.0 + eta;
            end
            else begin
                T2 = T0 + 1.0;
                T3 = T0 - 1.0;
            end
            RrsdTML = rhorsd * lt * T2 / (arsd_total * T3);
            if (HEPI < -1e-10) begin
                Rrsdside = RHOC / (-HEPI * TFIN * NFIN);
                Rrsd = (RrsdTML + Rsp) * Rrsdside / ((RrsdTML + Rsp) + Rrsdside);
            end
            else begin
                Rrsd = RrsdTML + Rsp;
            end
            Rdsgeo = Rrsd / NF * max(0.0,RGEOA + RGEOB * TFIN + RGEOC * FPITCH + RGEOD * LRSD + RGEOE * HEPI);
            RSourceGeo = Rdsgeo;
            RDrainGeo = Rdsgeo;
        end
        if (RSourceGeo <= 0.001) begin
            RSourceGeo = 0.001;
        end
        if (RDrainGeo <= 0.001) begin
            RDrainGeo = 0.001;
        end
        if (RDSMOD == 1) begin
            if (RSWMIN_i <= 0.0) begin
                RSWMIN_i = 0.0;
            end
            if (RDWMIN_i <= 0.0) begin
                RDWMIN_i = 0.0;
            end
            if (RSW_i <= 0.0) begin
                RSW_i = 0.0;
            end
            if (RDW_i <= 0.0) begin
                RDW_i = 0.0;
            end
        end
        else begin
            if (RDSWMIN_i <= 0.0) begin
                RDSWMIN_i = 0.0;
            end
            if (RDSW_i <= 0.0) begin
                RDSW_i = 0.0;
            end
        end
        if (CGEOMOD != 1) begin
            if ($param_given(CGSO)) begin
                CGSO_i = CGSO;
            end
            else begin
                if ($param_given(DLC) && DLC > 0.0) begin
                    CGSO_i = max(0.0,DLC * cox - CGSL_i);
                end
                else begin
                    CGSO_i = 0.3 * TFIN * cox;
                end
            end
            if ($param_given(CGDO)) begin
                CGDO_i = CGDO;
            end
            else begin
                if ($param_given(DLC) && DLC > 0.0) begin
                    CGDO_i = max(0.0,DLC * cox - CGDL_i);
                end
                else begin
                    CGDO_i = 0.3 * TFIN * cox;
                end
            end
        end
        if (CGEOMOD == 2) begin
            Hg = TGATE + TMASK;
            Trsd = 0.5 * (FPITCH - TFIN);
            Wg = max(0.0,Trsd - TOXP);
            Hrsd = max(0.0,HEPI + TSILI);
            if (TMASK > 0.0) begin
                _argR36_1_ = 1e-07 * EPSRSP / (3.9 * LSP);
                begin : llnE36
                    real lln;
                    real x_f2;

                    x_f2 = _argR36_1_;
                    lln = ln(max(x_f2,9.9999999999999996e-39));
                    llnE36 = lln;
                end
                T0 = 3.467e-11 * llnE36;
                T1 = 0.9419999999999999 * Hrsd * epssp / LSP;
                Cgg_top = (T0 + T1) * (TFIN + (FPITCH - TFIN) * CRATIO);
            end
            else begin
                begin : cfr_top_trigate
                    real Hr, Lr, Hgdelta, Lmax, y, x;
                    real CcgSat, Cnon, TT1, Ccg1, r1cf, Rcf, Ccg2;
                    real Ccg, C1, C2, C3, Cfglog, dcf, TT0;
                    real TT2, Cfgsat, delta, Cfg;

                    Hr = 2.3 + 0.2 * ((Hg) + (TOXP)) / (Hrsd);
                    Lr = 1.05;
                    Hgdelta = abs((Hg) + (TOXP) - (Hrsd));
                    Lmax = (LSP) * Lr;
                    y = min((Hrsd),(Hg) + (TOXP));
                    x = (LSP) / (Hr + 1.0);
                    Cnon = 1.700000000000e+12;
                    CcgSat = epssp * (y - x) / (LSP);
                    TT1 = Cnon * CcgSat;
                    if (TT1 > 80.0) Ccg1 = CcgSat;
                    else begin
                        _argR37_1_ = TT1;
                        begin : lexpE37
                            real lexp;
                            real x_f1;

                            x_f1 = _argR37_1_;
                            if (x_f1 > 80.0) begin
                                lexp = 5.540622384000e+34 * (1.0 + x_f1 - 80.0);
                            end
                            else if (x_f1 < -80.0) begin
                                lexp = 1.804851387e-35;
                            end
                            else begin
                                lexp = exp(x_f1);
                            end
                            lexpE37 = lexp;
                        end
                        Ccg1 = 1.0 / Cnon * ln(1.0 + lexpE37);
                    end
                    r1cf = 0.5 * min((Hrsd) / ((Hg) + (TOXP)),((Hg) + (TOXP)) / (Hrsd));
                    Rcf = Hgdelta * r1cf;
                    Ccg2 = epssp * 2 / 3.141592653589793 * ln(((LSP) + 0.5 * 3.141592653589793 * Rcf) / (LSP));
                    Ccg = (TFIN) * (Ccg1 + Ccg2);
                    x = Lmax / (Hg);
                    C1 = 4.0 / (sqrt(2.0 * (x + 1)) * 3.141592653589793);
                    C2 = sqrt((TOXP) * (TOXP) + 2.0 * (Hg) * (TOXP) + (Hg) * (Hg) * (x + 1)) * sqrt(x + 1) + (TOXP) + (Hg) * x + (Hg);
                    C3 = (TOXP) * sqrt((x + 1) * (x + 4)) + TOXP * (x + 2);
                    Cfglog = epssp * (C1 * ln(C2 / C3) + 12.27);
                    dcf = Hr * Lr;
                    TT0 = sqrt(dcf * dcf + 1.0);
                    TT1 = sqrt((dcf * dcf + 1) * ((dcf * (TOXP)) * (dcf * (TOXP)) + 2 * dcf * Lmax * (TOXP) + (dcf * dcf + 1) * Lmax * Lmax)) + dcf * (TOXP) + dcf * dcf * Lmax + Lmax;
                    TT2 = (TT0 + 1.0) * (dcf * (TOXP));
                    Cfgsat = 2.0 * epssp * sqrt(2) / 3.141592653589793 * (0.85) * dcf / TT0 * ln(TT1 / TT2);
                    delta = 1.2e-12;
                    TT1 = Cfgsat - Cfglog - delta;
                    Cfg = (TFIN) * (Cfgsat - 0.5 * (TT1 + sqrt(TT1 * TT1 + 4 * delta * Cfgsat)));
                    Cgg_top = Ccg + Cfg;
                end
            end
            if (TMASK > 0) begin
                begin : cfr_side_dblgate
                    real Hr, Lr, Hgdelta, Lmax, y, x;
                    real CcgSat, Cnon, TT1, Ccg1, r1cf, Rcf, Ccg2;
                    real Ccg, C1, C2, C3, Cfglog, dcf, TT0;
                    real TT2, Cfgsat, delta, Cfg;

                    Hr = 2.3 + 0.2 * ((Wg) + (TOXP)) / (Trsd);
                    Lr = 1.05;
                    Hgdelta = abs((Wg) + (TOXP) - (Trsd));
                    Lmax = (LSP) * Lr;
                    y = min((Trsd),(Wg) + (TOXP));
                    x = (LSP) / (Hr + 1.0);
                    Cnon = 1.700000000000e+12;
                    CcgSat = epssp * (y - x) / (LSP);
                    TT1 = Cnon * CcgSat;
                    if (TT1 > 80.0) Ccg1 = CcgSat;
                    else begin
                        _argR38_1_ = TT1;
                        begin : lexpE38
                            real lexp;
                            real x_f1;

                            x_f1 = _argR38_1_;
                            if (x_f1 > 80.0) begin
                                lexp = 5.540622384000e+34 * (1.0 + x_f1 - 80.0);
                            end
                            else if (x_f1 < -80.0) begin
                                lexp = 1.804851387e-35;
                            end
                            else begin
                                lexp = exp(x_f1);
                            end
                            lexpE38 = lexp;
                        end
                        Ccg1 = 1.0 / Cnon * ln(1.0 + lexpE38);
                    end
                    r1cf = 0.5 * min((Trsd) / ((Wg) + (TOXP)),((Wg) + (TOXP)) / (Trsd));
                    Rcf = Hgdelta * r1cf;
                    Ccg2 = epssp * 2 / 3.141592653589793 * ln(((LSP) + 0.5 * 3.141592653589793 * Rcf) / (LSP));
                    Ccg = (HFIN) * (Ccg1 + Ccg2);
                    x = Lmax / (Wg);
                    C1 = 4.0 / (sqrt(2.0 * (x + 1)) * 3.141592653589793);
                    C2 = sqrt((TOXP) * (TOXP) + 2.0 * (Wg) * (TOXP) + (Wg) * (Wg) * (x + 1)) * sqrt(x + 1) + (TOXP) + (Wg) * x + (Wg);
                    C3 = (TOXP) * sqrt((x + 1) * (x + 4)) + TOXP * (x + 2);
                    Cfglog = epssp * (C1 * ln(C2 / C3) + 12.27);
                    dcf = Hr * Lr;
                    TT0 = sqrt(dcf * dcf + 1.0);
                    TT1 = sqrt((dcf * dcf + 1) * ((dcf * (TOXP)) * (dcf * (TOXP)) + 2 * dcf * Lmax * (TOXP) + (dcf * dcf + 1) * Lmax * Lmax)) + dcf * (TOXP) + dcf * dcf * Lmax + Lmax;
                    TT2 = (TT0 + 1.0) * (dcf * (TOXP));
                    Cfgsat = 2.0 * epssp * sqrt(2) / 3.141592653589793 * (0.7) * dcf / TT0 * ln(TT1 / TT2);
                    delta = 1.2e-12;
                    TT1 = Cfgsat - Cfglog - delta;
                    Cfg = (HFIN) * (Cfgsat - 0.5 * (TT1 + sqrt(TT1 * TT1 + 4 * delta * Cfgsat)));
                    Cgg_side = Ccg + Cfg;
                end
            end
            else begin
                begin : cfr_side_trigate
                    real Hr, Lr, Hgdelta, Lmax, y, x;
                    real CcgSat, Cnon, TT1, Ccg1, r1cf, Rcf, Ccg2;
                    real Ccg, C1, C2, C3, Cfglog, dcf, TT0;
                    real TT2, Cfgsat, delta, Cfg;

                    Hr = 2.3 + 0.2 * ((Wg) + (TOXP)) / (Trsd);
                    Lr = 1.05;
                    Hgdelta = abs((Wg) + (TOXP) - (Trsd));
                    Lmax = (LSP) * Lr;
                    y = min((Trsd),(Wg) + (TOXP));
                    x = (LSP) / (Hr + 1.0);
                    Cnon = 1.700000000000e+12;
                    CcgSat = epssp * (y - x) / (LSP);
                    TT1 = Cnon * CcgSat;
                    if (TT1 > 80.0) Ccg1 = CcgSat;
                    else begin
                        _argR39_1_ = TT1;
                        begin : lexpE39
                            real lexp;
                            real x_f1;

                            x_f1 = _argR39_1_;
                            if (x_f1 > 80.0) begin
                                lexp = 5.540622384000e+34 * (1.0 + x_f1 - 80.0);
                            end
                            else if (x_f1 < -80.0) begin
                                lexp = 1.804851387e-35;
                            end
                            else begin
                                lexp = exp(x_f1);
                            end
                            lexpE39 = lexp;
                        end
                        Ccg1 = 1.0 / Cnon * ln(1.0 + lexpE39);
                    end
                    r1cf = 0.5 * min((Trsd) / ((Wg) + (TOXP)),((Wg) + (TOXP)) / (Trsd));
                    Rcf = Hgdelta * r1cf;
                    Ccg2 = epssp * 2 / 3.141592653589793 * ln(((LSP) + 0.5 * 3.141592653589793 * Rcf) / (LSP));
                    Ccg = (HFIN) * (Ccg1 + Ccg2);
                    x = Lmax / (Wg);
                    C1 = 4.0 / (sqrt(2.0 * (x + 1)) * 3.141592653589793);
                    C2 = sqrt((TOXP) * (TOXP) + 2.0 * (Wg) * (TOXP) + (Wg) * (Wg) * (x + 1)) * sqrt(x + 1) + (TOXP) + (Wg) * x + (Wg);
                    C3 = (TOXP) * sqrt((x + 1) * (x + 4)) + TOXP * (x + 2);
                    Cfglog = epssp * (C1 * ln(C2 / C3) + 12.27);
                    dcf = Hr * Lr;
                    TT0 = sqrt(dcf * dcf + 1.0);
                    TT1 = sqrt((dcf * dcf + 1) * ((dcf * (TOXP)) * (dcf * (TOXP)) + 2 * dcf * Lmax * (TOXP) + (dcf * dcf + 1) * Lmax * Lmax)) + dcf * (TOXP) + dcf * dcf * Lmax + Lmax;
                    TT2 = (TT0 + 1.0) * (dcf * (TOXP));
                    Cfgsat = 2.0 * epssp * sqrt(2) / 3.141592653589793 * (0.85) * dcf / TT0 * ln(TT1 / TT2);
                    delta = 1.2e-12;
                    TT1 = Cfgsat - Cfglog - delta;
                    Cfg = (HFIN) * (Cfgsat - 0.5 * (TT1 + sqrt(TT1 * TT1 + 4 * delta * Cfgsat)));
                    Cgg_side = Ccg + Cfg;
                end
            end
            if (TMASK > 0.0) begin
                Acorner = 0.0;
            end
            else begin
                if (HEPI > 0.0) begin
                    Acorner = (FPITCH - TFIN) * (HEPI * CRATIO + TSILI);
                end
                else begin
                    Acorner = (FPITCH - TFIN) * Hrsd;
                end
            end
            Ccorner = (NFIN * Acorner + ARSDEND + ASILIEND) * epssp / LSP;
            Cfr_geo = (Ccorner + Cgg_top * NFIN + CGEOE * Cgg_side * NFIN * 2.0) * NF;
            Cfr_geo = Cfr_geo * max(0.0,CGEOA + CGEOB * TFIN + CGEOC * FPITCH + CGEOD * LRSD);
        end
        _argR40_1_ = 1.0 + HFIN / EOTBOX;
        begin : llnE40
            real lln;
            real x_f2;

            x_f2 = _argR40_1_;
            lln = ln(max(x_f2,9.9999999999999996e-39));
            llnE40 = lln;
        end
        T0 = CSDESW * llnE40;
        csbox = cbox * ASEO + T0 * max(0.0,PSEO - FPITCH * NFINtotal);
        cdbox = cbox * ADEO + T0 * max(0.0,PDEO - FPITCH * NFINtotal);
        cgbox = (CGBO * NF * NGCON + CGBN * NFINtotal) * Lg;
        EeffFactor = 1e-08 / (epsratio * (EOT));
        WeffWRFactor = 1.0 / (pow((Weff0) * 1000000.0,WR_i) * NFINtotal);
        litl = sqrt(epsratio * EOT * 0.5 * TFIN);
        if (!$param_given(THETASCE)) begin
            tmp = DVT1_i * Leff / scl + 1e-06;
            if (tmp < 40.0) begin
                Theta_SCE = 0.5 / (cosh(tmp) - 1.0);
            end
            else begin
                Theta_SCE = exp(-tmp);
            end
        end
        else begin
            Theta_SCE = THETASCE;
        end
        if (!$param_given(THETASW)) begin
            tmp = DVT1SS_i * Leff / scl + 1e-06;
            if (tmp < 40.0) begin
                Theta_SW = 0.5 / (cosh(tmp) - 1.0);
            end
            else begin
                Theta_SW = exp(-tmp);
            end
        end
        else begin
            Theta_SW = THETASW;
        end
        if (!$param_given(THETADIBL)) begin
            tmp = DSUB_i * Leff / scl + 1e-06;
            if (tmp < 40.0) begin
                Theta_DIBL = 0.5 / (cosh(tmp) - 1.0);
            end
            else begin
                Theta_DIBL = exp(-tmp);
            end
        end
        else begin
            Theta_DIBL = THETADIBL;
        end
        Theta_RSCE = sqrt(1.0 + LPE0_i / Leff) - 1.0;
        tmp = DSUB_i * Leff / scl + 1e-06;
        if (tmp < 40.0) begin
            T0 = 1.0 / max((1.0 + DVTP2 * (cosh(tmp) - 2.0)),1e-06);
        end
        else begin
            T0 = exp(-tmp) / max((exp(-tmp) + DVTP2),1e-06);
        end
        Theta_DITS = T0;
        nbody = NBODY_i;
        qbs = 1.6021899999999999e-19 * nbody * Ach / Cins;
        if (TYPE == 1) begin
            Aechvb = 4.97232e-07;
            Bechvb = 7.456690000000e+11;
        end
        else begin
            Aechvb = 3.42537e-07;
            Bechvb = 1.166450000000e+12;
        end
        T0 = TOXG * TOXG;
        T1 = TOXG * POXEDGE_i;
        T2 = T1 * T1;
        _argR41_1_ = TOXREF / TOXG;
        begin : llnE41
            real lln;
            real x_f2;

            x_f2 = _argR41_1_;
            lln = ln(max(x_f2,9.9999999999999996e-39));
            llnE41 = lln;
        end
        _argR42_1_ = NTOX_i * llnE41;
        begin : lexpE42
            real lexp;
            real x_f1;

            x_f1 = _argR42_1_;
            if (x_f1 > 80.0) begin
                lexp = 5.540622384000e+34 * (1.0 + x_f1 - 80.0);
            end
            else if (x_f1 < -80.0) begin
                lexp = 1.804851387e-35;
            end
            else begin
                lexp = exp(x_f1);
            end
            lexpE42 = lexp;
        end
        Toxratio = lexpE42 / T0;
        _argR43_1_ = TOXREF / T1;
        begin : llnE43
            real lln;
            real x_f2;

            x_f2 = _argR43_1_;
            lln = ln(max(x_f2,9.9999999999999996e-39));
            llnE43 = lln;
        end
        _argR44_1_ = NTOX_i * llnE43;
        begin : lexpE44
            real lexp;
            real x_f1;

            x_f1 = _argR44_1_;
            if (x_f1 > 80.0) begin
                lexp = 5.540622384000e+34 * (1.0 + x_f1 - 80.0);
            end
            else if (x_f1 < -80.0) begin
                lexp = 1.804851387e-35;
            end
            else begin
                lexp = exp(x_f1);
            end
            lexpE44 = lexp;
        end
        Toxratioedge = lexpE44 / T2;
        igsd_mult0 = Weff0 * Aechvb * Toxratioedge;
        if (TNOM < -273.15) begin
            $strobe("Warning: (TNOM=%e) < -`P_CELSIUS0. Set to 27 C.",TNOM);
            Tnom = (300.15);
        end
        else begin
            Tnom = TNOM + (273.15);
        end
    end
    if (SHMOD != 0 && RTH0 > 0.0) begin
        DevTemp = $temperature + Temp(rth_branch) + DTEMP;
    end
    else begin
        DevTemp = $temperature + DTEMP;
    end
    begin : CMGTempDepCalc
        TRatio = DevTemp / Tnom;
        delTemp = DevTemp - Tnom;
        Vtm = 8.617087e-05 * DevTemp;
        Vtm0 = 8.617087e-05 * Tnom;
        Eg = BG0SUB - TBGASUB * DevTemp * DevTemp / (DevTemp + TBGBSUB);
        Eg0 = BG0SUB - TBGASUB * Tnom * Tnom / (Tnom + TBGBSUB);
        T1 = (DevTemp / 300.15) * sqrt(DevTemp / 300.15);
        _argR45_1_ = BG0SUB / (2.0 * 8.617087e-05 * 300.15) - Eg / (2.0 * Vtm);
        begin : lexpE45
            real lexp;
            real x_f1;

            x_f1 = _argR45_1_;
            if (x_f1 > 80.0) begin
                lexp = 5.540622384000e+34 * (1.0 + x_f1 - 80.0);
            end
            else if (x_f1 < -80.0) begin
                lexp = 1.804851387e-35;
            end
            else begin
                lexp = exp(x_f1);
            end
            lexpE45 = lexp;
        end
        ni = NI0SUB * T1 * lexpE45;
        Nc = NC0SUB * T1;
        _argR46_1_ = 1.0 + TSS_i * delTemp - 1e-06;
        _argR46_2_ = 0.001;
        begin : hypsmoothE46
            real hypsmooth;
            real x_f3, c_f3;

            x_f3 = _argR46_1_;
            c_f3 = _argR46_2_;
            hypsmooth = 0.5 * (x_f3 + sqrt(x_f3 * x_f3 + 4.0 * c_f3 * c_f3));
            hypsmoothE46 = hypsmooth;
        end
        ThetaSS = hypsmoothE46;
        kT = Vtm * 1.6021899999999999e-19;
        T0 = 1.05457e-34 * 3.141592653589793 / (2 * Ach / Weff_UFCM);
        E0 = T0 * T0 / (2.0 * mx);
        E0prime = T0 * T0 / (2.0 * mxprime);
        E1 = 4.0 * E0;
        E1prime = 4.0 * E0prime;
        T1 = gprime * mdprime / (gfactor * md);
        _argR47_1_ = (E0 - E0prime) / kT;
        begin : lexpE47
            real lexp;
            real x_f1;

            x_f1 = _argR47_1_;
            if (x_f1 > 80.0) begin
                lexp = 5.540622384000e+34 * (1.0 + x_f1 - 80.0);
            end
            else if (x_f1 < -80.0) begin
                lexp = 1.804851387e-35;
            end
            else begin
                lexp = exp(x_f1);
            end
            lexpE47 = lexp;
        end
        gam0 = 1.0 + T1 * lexpE47;
        _argR48_1_ = (E0 - E1) / kT;
        begin : lexpE48
            real lexp;
            real x_f1;

            x_f1 = _argR48_1_;
            if (x_f1 > 80.0) begin
                lexp = 5.540622384000e+34 * (1.0 + x_f1 - 80.0);
            end
            else if (x_f1 < -80.0) begin
                lexp = 1.804851387e-35;
            end
            else begin
                lexp = exp(x_f1);
            end
            lexpE48 = lexp;
        end
        _argR49_1_ = (E0 - E1prime) / kT;
        begin : lexpE49
            real lexp;
            real x_f1;

            x_f1 = _argR49_1_;
            if (x_f1 > 80.0) begin
                lexp = 5.540622384000e+34 * (1.0 + x_f1 - 80.0);
            end
            else if (x_f1 < -80.0) begin
                lexp = 1.804851387e-35;
            end
            else begin
                lexp = exp(x_f1);
            end
            lexpE49 = lexp;
        end
        gam1 = gam0 + lexpE48 + T1 * lexpE49;
        _argR50_1_ = gfactor * md / (3.141592653589793 * 1.05457e-34 * 1.05457e-34 * Nc) * kT / (2.0 * Ach / Weff_UFCM) * gam1;
        begin : llnE50
            real lln;
            real x_f2;

            x_f2 = _argR50_1_;
            lln = ln(max(x_f2,9.9999999999999996e-39));
            llnE50 = lln;
        end
        T2 = -Vtm * llnE50;
        dvch_qm = QMFACTOR_i * (E0 / 1.6021899999999999e-19 + T2);
        _argR51_1_ = ETA0_i;
        _argR51_2_ = TETA0;
        _argR51_3_ = delTemp;
        _argR51_4_ = TEMPMOD;
        begin : TempdepE51
            real Tempdep;
            real PARAML_f5, PARAMT_f5, DELTEMP_f5, TEMPMOD_f5;

            PARAML_f5 = _argR51_1_;
            PARAMT_f5 = _argR51_2_;
            DELTEMP_f5 = _argR51_3_;
            TEMPMOD_f5 = _argR51_4_;
            if (TEMPMOD_f5 != 0) begin
                _argR1_1_ = PARAMT_f5 * DELTEMP_f5;
                _argR1_2_ = -PARAML_f5;
                _argR1_3_ = 1e-06;
                begin : hypmaxE01
                    real hypmax;
                    real x_f4, xmin_f4, c_f4;

                    x_f4 = _argR1_1_;
                    xmin_f4 = _argR1_2_;
                    c_f4 = _argR1_3_;
                    hypmax = xmin_f4 + 0.5 * (x_f4 - xmin_f4 - c_f4 + sqrt((x_f4 - xmin_f4 - c_f4) * (x_f4 - xmin_f4 - c_f4) - 4.0 * xmin_f4 * c_f4));
                    hypmaxE01 = hypmax;
                end
                Tempdep = PARAML_f5 + hypmaxE01;
            end
            else begin
                _argR2_1_ = 1.0 + PARAMT_f5 * DELTEMP_f5 - 1e-06;
                _argR2_2_ = 0.001;
                begin : hypsmoothE02
                    real hypsmooth;
                    real x_f3, c_f3;

                    x_f3 = _argR2_1_;
                    c_f3 = _argR2_2_;
                    hypsmooth = 0.5 * (x_f3 + sqrt(x_f3 * x_f3 + 4.0 * c_f3 * c_f3));
                    hypsmoothE02 = hypsmooth;
                end
                Tempdep = PARAML_f5 * hypsmoothE02;
            end
            TempdepE51 = Tempdep;
        end
        ETA0_t = TempdepE51;
        _argR52_1_ = ETA0R_i;
        _argR52_2_ = TETA0R;
        _argR52_3_ = delTemp;
        _argR52_4_ = TEMPMOD;
        begin : TempdepE52
            real Tempdep;
            real PARAML_f5, PARAMT_f5, DELTEMP_f5, TEMPMOD_f5;

            PARAML_f5 = _argR52_1_;
            PARAMT_f5 = _argR52_2_;
            DELTEMP_f5 = _argR52_3_;
            TEMPMOD_f5 = _argR52_4_;
            if (TEMPMOD_f5 != 0) begin
                _argR1_1_ = PARAMT_f5 * DELTEMP_f5;
                _argR1_2_ = -PARAML_f5;
                _argR1_3_ = 1e-06;
                begin : hypmaxE01
                    real hypmax;
                    real x_f4, xmin_f4, c_f4;

                    x_f4 = _argR1_1_;
                    xmin_f4 = _argR1_2_;
                    c_f4 = _argR1_3_;
                    hypmax = xmin_f4 + 0.5 * (x_f4 - xmin_f4 - c_f4 + sqrt((x_f4 - xmin_f4 - c_f4) * (x_f4 - xmin_f4 - c_f4) - 4.0 * xmin_f4 * c_f4));
                    hypmaxE01 = hypmax;
                end
                Tempdep = PARAML_f5 + hypmaxE01;
            end
            else begin
                _argR2_1_ = 1.0 + PARAMT_f5 * DELTEMP_f5 - 1e-06;
                _argR2_2_ = 0.001;
                begin : hypsmoothE02
                    real hypsmooth;
                    real x_f3, c_f3;

                    x_f3 = _argR2_1_;
                    c_f3 = _argR2_2_;
                    hypsmooth = 0.5 * (x_f3 + sqrt(x_f3 * x_f3 + 4.0 * c_f3 * c_f3));
                    hypsmoothE02 = hypsmooth;
                end
                Tempdep = PARAML_f5 * hypsmoothE02;
            end
            TempdepE52 = Tempdep;
        end
        ETA0R_t = TempdepE52;
        T1 = U0_i * pow(TRatio,UTE_i);
        _argR53_1_ = UTL_i * delTemp;
        _argR53_2_ = -0.9 * T1;
        _argR53_3_ = 0.0001;
        begin : hypmaxE53
            real hypmax;
            real x_f4, xmin_f4, c_f4;

            x_f4 = _argR53_1_;
            xmin_f4 = _argR53_2_;
            c_f4 = _argR53_3_;
            hypmax = xmin_f4 + 0.5 * (x_f4 - xmin_f4 - c_f4 + sqrt((x_f4 - xmin_f4 - c_f4) * (x_f4 - xmin_f4 - c_f4) - 4.0 * xmin_f4 * c_f4));
            hypmaxE53 = hypmax;
        end
        U0_t = T1 + hypmaxE53;
        u0 = U0_t;
        if (ASYMMOD == 1) begin
            T1 = U0R_i * pow(TRatio,UTER_i);
            _argR54_1_ = UTLR_i * delTemp;
            _argR54_2_ = -0.9 * T1;
            _argR54_3_ = 0.0001;
            begin : hypmaxE54
                real hypmax;
                real x_f4, xmin_f4, c_f4;

                x_f4 = _argR54_1_;
                xmin_f4 = _argR54_2_;
                c_f4 = _argR54_3_;
                hypmax = xmin_f4 + 0.5 * (x_f4 - xmin_f4 - c_f4 + sqrt((x_f4 - xmin_f4 - c_f4) * (x_f4 - xmin_f4 - c_f4) - 4.0 * xmin_f4 * c_f4));
                hypmaxE54 = hypmax;
            end
            U0R_t = T1 + hypmaxE54;
            u0r = U0R_t;
        end
        _argR55_1_ = ETAMOB_i;
        _argR55_2_ = EMOBT_i;
        _argR55_3_ = delTemp;
        _argR55_4_ = TEMPMOD;
        begin : TempdepE55
            real Tempdep;
            real PARAML_f5, PARAMT_f5, DELTEMP_f5, TEMPMOD_f5;

            PARAML_f5 = _argR55_1_;
            PARAMT_f5 = _argR55_2_;
            DELTEMP_f5 = _argR55_3_;
            TEMPMOD_f5 = _argR55_4_;
            if (TEMPMOD_f5 != 0) begin
                _argR1_1_ = PARAMT_f5 * DELTEMP_f5;
                _argR1_2_ = -PARAML_f5;
                _argR1_3_ = 1e-06;
                begin : hypmaxE01
                    real hypmax;
                    real x_f4, xmin_f4, c_f4;

                    x_f4 = _argR1_1_;
                    xmin_f4 = _argR1_2_;
                    c_f4 = _argR1_3_;
                    hypmax = xmin_f4 + 0.5 * (x_f4 - xmin_f4 - c_f4 + sqrt((x_f4 - xmin_f4 - c_f4) * (x_f4 - xmin_f4 - c_f4) - 4.0 * xmin_f4 * c_f4));
                    hypmaxE01 = hypmax;
                end
                Tempdep = PARAML_f5 + hypmaxE01;
            end
            else begin
                _argR2_1_ = 1.0 + PARAMT_f5 * DELTEMP_f5 - 1e-06;
                _argR2_2_ = 0.001;
                begin : hypsmoothE02
                    real hypsmooth;
                    real x_f3, c_f3;

                    x_f3 = _argR2_1_;
                    c_f3 = _argR2_2_;
                    hypsmooth = 0.5 * (x_f3 + sqrt(x_f3 * x_f3 + 4.0 * c_f3 * c_f3));
                    hypsmoothE02 = hypsmooth;
                end
                Tempdep = PARAML_f5 * hypsmoothE02;
            end
            TempdepE55 = Tempdep;
        end
        ETAMOB_t = TempdepE55;
        _argR56_1_ = UA1_i * delTemp;
        _argR56_2_ = -UA_i;
        _argR56_3_ = 1e-06;
        begin : hypmaxE56
            real hypmax;
            real x_f4, xmin_f4, c_f4;

            x_f4 = _argR56_1_;
            xmin_f4 = _argR56_2_;
            c_f4 = _argR56_3_;
            hypmax = xmin_f4 + 0.5 * (x_f4 - xmin_f4 - c_f4 + sqrt((x_f4 - xmin_f4 - c_f4) * (x_f4 - xmin_f4 - c_f4) - 4.0 * xmin_f4 * c_f4));
            hypmaxE56 = hypmax;
        end
        UA_t = UA_i + hypmaxE56;
        if (ASYMMOD != 0) begin
            _argR57_1_ = UA1R_i * delTemp;
            _argR57_2_ = -UAR_i;
            _argR57_3_ = 1e-06;
            begin : hypmaxE57
                real hypmax;
                real x_f4, xmin_f4, c_f4;

                x_f4 = _argR57_1_;
                xmin_f4 = _argR57_2_;
                c_f4 = _argR57_3_;
                hypmax = xmin_f4 + 0.5 * (x_f4 - xmin_f4 - c_f4 + sqrt((x_f4 - xmin_f4 - c_f4) * (x_f4 - xmin_f4 - c_f4) - 4.0 * xmin_f4 * c_f4));
                hypmaxE57 = hypmax;
            end
            UAR_t = UAR_i + hypmaxE57;
        end
        if (BULKMOD != 0) begin
            if (TEMPMOD == 0) begin
                _argR58_1_ = UC_i;
                _argR58_2_ = UC1_i;
                _argR58_3_ = delTemp;
                _argR58_4_ = 0;
                begin : TempdepE58
                    real Tempdep;
                    real PARAML_f5, PARAMT_f5, DELTEMP_f5, TEMPMOD_f5;

                    PARAML_f5 = _argR58_1_;
                    PARAMT_f5 = _argR58_2_;
                    DELTEMP_f5 = _argR58_3_;
                    TEMPMOD_f5 = _argR58_4_;
                    if (TEMPMOD_f5 != 0) begin
                        _argR1_1_ = PARAMT_f5 * DELTEMP_f5;
                        _argR1_2_ = -PARAML_f5;
                        _argR1_3_ = 1e-06;
                        begin : hypmaxE01
                            real hypmax;
                            real x_f4, xmin_f4, c_f4;

                            x_f4 = _argR1_1_;
                            xmin_f4 = _argR1_2_;
                            c_f4 = _argR1_3_;
                            hypmax = xmin_f4 + 0.5 * (x_f4 - xmin_f4 - c_f4 + sqrt((x_f4 - xmin_f4 - c_f4) * (x_f4 - xmin_f4 - c_f4) - 4.0 * xmin_f4 * c_f4));
                            hypmaxE01 = hypmax;
                        end
                        Tempdep = PARAML_f5 + hypmaxE01;
                    end
                    else begin
                        _argR2_1_ = 1.0 + PARAMT_f5 * DELTEMP_f5 - 1e-06;
                        _argR2_2_ = 0.001;
                        begin : hypsmoothE02
                            real hypsmooth;
                            real x_f3, c_f3;

                            x_f3 = _argR2_1_;
                            c_f3 = _argR2_2_;
                            hypsmooth = 0.5 * (x_f3 + sqrt(x_f3 * x_f3 + 4.0 * c_f3 * c_f3));
                            hypsmoothE02 = hypsmooth;
                        end
                        Tempdep = PARAML_f5 * hypsmoothE02;
                    end
                    TempdepE58 = Tempdep;
                end
                UC_t = TempdepE58;
                if (ASYMMOD != 0) begin
                    _argR59_1_ = UCR_i;
                    _argR59_2_ = UC1R_i;
                    _argR59_3_ = delTemp;
                    _argR59_4_ = 0;
                    begin : TempdepE59
                        real Tempdep;
                        real PARAML_f5, PARAMT_f5, DELTEMP_f5, TEMPMOD_f5;

                        PARAML_f5 = _argR59_1_;
                        PARAMT_f5 = _argR59_2_;
                        DELTEMP_f5 = _argR59_3_;
                        TEMPMOD_f5 = _argR59_4_;
                        if (TEMPMOD_f5 != 0) begin
                            _argR1_1_ = PARAMT_f5 * DELTEMP_f5;
                            _argR1_2_ = -PARAML_f5;
                            _argR1_3_ = 1e-06;
                            begin : hypmaxE01
                                real hypmax;
                                real x_f4, xmin_f4, c_f4;

                                x_f4 = _argR1_1_;
                                xmin_f4 = _argR1_2_;
                                c_f4 = _argR1_3_;
                                hypmax = xmin_f4 + 0.5 * (x_f4 - xmin_f4 - c_f4 + sqrt((x_f4 - xmin_f4 - c_f4) * (x_f4 - xmin_f4 - c_f4) - 4.0 * xmin_f4 * c_f4));
                                hypmaxE01 = hypmax;
                            end
                            Tempdep = PARAML_f5 + hypmaxE01;
                        end
                        else begin
                            _argR2_1_ = 1.0 + PARAMT_f5 * DELTEMP_f5 - 1e-06;
                            _argR2_2_ = 0.001;
                            begin : hypsmoothE02
                                real hypsmooth;
                                real x_f3, c_f3;

                                x_f3 = _argR2_1_;
                                c_f3 = _argR2_2_;
                                hypsmooth = 0.5 * (x_f3 + sqrt(x_f3 * x_f3 + 4.0 * c_f3 * c_f3));
                                hypsmoothE02 = hypsmooth;
                            end
                            Tempdep = PARAML_f5 * hypsmoothE02;
                        end
                        TempdepE59 = Tempdep;
                    end
                    UCR_t = TempdepE59;
                end
            end
            else begin
                UC_t = UC_i + UC1_i * delTemp;
                if (ASYMMOD != 0) begin
                    UCR_t = UCR_i + UC1R_i * delTemp;
                end
            end
        end
        UD_t = UD_i * pow(TRatio,UD1_i);
        if (ASYMMOD != 0) begin
            UDR_t = UDR_i * pow(TRatio,UD1R_i);
        end
        UCS_t = UCS_i * pow(TRatio,UCSTE_i);
        _argR60_1_ = 1.0 + PRT_i * delTemp - 1e-06;
        _argR60_2_ = 0.001;
        begin : hypsmoothE60
            real hypsmooth;
            real x_f3, c_f3;

            x_f3 = _argR60_1_;
            c_f3 = _argR60_2_;
            hypsmooth = 0.5 * (x_f3 + sqrt(x_f3 * x_f3 + 4.0 * c_f3 * c_f3));
            hypsmoothE60 = hypsmooth;
        end
        rdstemp = hypsmoothE60;
        _argR61_1_ = RSDR;
        _argR61_2_ = TRSDR;
        _argR61_3_ = delTemp;
        _argR61_4_ = TEMPMOD;
        begin : TempdepE61
            real Tempdep;
            real PARAML_f5, PARAMT_f5, DELTEMP_f5, TEMPMOD_f5;

            PARAML_f5 = _argR61_1_;
            PARAMT_f5 = _argR61_2_;
            DELTEMP_f5 = _argR61_3_;
            TEMPMOD_f5 = _argR61_4_;
            if (TEMPMOD_f5 != 0) begin
                _argR1_1_ = PARAMT_f5 * DELTEMP_f5;
                _argR1_2_ = -PARAML_f5;
                _argR1_3_ = 1e-06;
                begin : hypmaxE01
                    real hypmax;
                    real x_f4, xmin_f4, c_f4;

                    x_f4 = _argR1_1_;
                    xmin_f4 = _argR1_2_;
                    c_f4 = _argR1_3_;
                    hypmax = xmin_f4 + 0.5 * (x_f4 - xmin_f4 - c_f4 + sqrt((x_f4 - xmin_f4 - c_f4) * (x_f4 - xmin_f4 - c_f4) - 4.0 * xmin_f4 * c_f4));
                    hypmaxE01 = hypmax;
                end
                Tempdep = PARAML_f5 + hypmaxE01;
            end
            else begin
                _argR2_1_ = 1.0 + PARAMT_f5 * DELTEMP_f5 - 1e-06;
                _argR2_2_ = 0.001;
                begin : hypsmoothE02
                    real hypsmooth;
                    real x_f3, c_f3;

                    x_f3 = _argR2_1_;
                    c_f3 = _argR2_2_;
                    hypsmooth = 0.5 * (x_f3 + sqrt(x_f3 * x_f3 + 4.0 * c_f3 * c_f3));
                    hypsmoothE02 = hypsmooth;
                end
                Tempdep = PARAML_f5 * hypsmoothE02;
            end
            TempdepE61 = Tempdep;
        end
        RSDR_t = TempdepE61;
        if (ASYMMOD != 0) begin
            _argR62_1_ = RSDRR;
            _argR62_2_ = TRSDR;
            _argR62_3_ = delTemp;
            _argR62_4_ = TEMPMOD;
            begin : TempdepE62
                real Tempdep;
                real PARAML_f5, PARAMT_f5, DELTEMP_f5, TEMPMOD_f5;

                PARAML_f5 = _argR62_1_;
                PARAMT_f5 = _argR62_2_;
                DELTEMP_f5 = _argR62_3_;
                TEMPMOD_f5 = _argR62_4_;
                if (TEMPMOD_f5 != 0) begin
                    _argR1_1_ = PARAMT_f5 * DELTEMP_f5;
                    _argR1_2_ = -PARAML_f5;
                    _argR1_3_ = 1e-06;
                    begin : hypmaxE01
                        real hypmax;
                        real x_f4, xmin_f4, c_f4;

                        x_f4 = _argR1_1_;
                        xmin_f4 = _argR1_2_;
                        c_f4 = _argR1_3_;
                        hypmax = xmin_f4 + 0.5 * (x_f4 - xmin_f4 - c_f4 + sqrt((x_f4 - xmin_f4 - c_f4) * (x_f4 - xmin_f4 - c_f4) - 4.0 * xmin_f4 * c_f4));
                        hypmaxE01 = hypmax;
                    end
                    Tempdep = PARAML_f5 + hypmaxE01;
                end
                else begin
                    _argR2_1_ = 1.0 + PARAMT_f5 * DELTEMP_f5 - 1e-06;
                    _argR2_2_ = 0.001;
                    begin : hypsmoothE02
                        real hypsmooth;
                        real x_f3, c_f3;

                        x_f3 = _argR2_1_;
                        c_f3 = _argR2_2_;
                        hypsmooth = 0.5 * (x_f3 + sqrt(x_f3 * x_f3 + 4.0 * c_f3 * c_f3));
                        hypsmoothE02 = hypsmooth;
                    end
                    Tempdep = PARAML_f5 * hypsmoothE02;
                end
                TempdepE62 = Tempdep;
            end
            RSDRR_t = TempdepE62;
        end
        _argR63_1_ = RDDR;
        _argR63_2_ = TRDDR;
        _argR63_3_ = delTemp;
        _argR63_4_ = TEMPMOD;
        begin : TempdepE63
            real Tempdep;
            real PARAML_f5, PARAMT_f5, DELTEMP_f5, TEMPMOD_f5;

            PARAML_f5 = _argR63_1_;
            PARAMT_f5 = _argR63_2_;
            DELTEMP_f5 = _argR63_3_;
            TEMPMOD_f5 = _argR63_4_;
            if (TEMPMOD_f5 != 0) begin
                _argR1_1_ = PARAMT_f5 * DELTEMP_f5;
                _argR1_2_ = -PARAML_f5;
                _argR1_3_ = 1e-06;
                begin : hypmaxE01
                    real hypmax;
                    real x_f4, xmin_f4, c_f4;

                    x_f4 = _argR1_1_;
                    xmin_f4 = _argR1_2_;
                    c_f4 = _argR1_3_;
                    hypmax = xmin_f4 + 0.5 * (x_f4 - xmin_f4 - c_f4 + sqrt((x_f4 - xmin_f4 - c_f4) * (x_f4 - xmin_f4 - c_f4) - 4.0 * xmin_f4 * c_f4));
                    hypmaxE01 = hypmax;
                end
                Tempdep = PARAML_f5 + hypmaxE01;
            end
            else begin
                _argR2_1_ = 1.0 + PARAMT_f5 * DELTEMP_f5 - 1e-06;
                _argR2_2_ = 0.001;
                begin : hypsmoothE02
                    real hypsmooth;
                    real x_f3, c_f3;

                    x_f3 = _argR2_1_;
                    c_f3 = _argR2_2_;
                    hypsmooth = 0.5 * (x_f3 + sqrt(x_f3 * x_f3 + 4.0 * c_f3 * c_f3));
                    hypsmoothE02 = hypsmooth;
                end
                Tempdep = PARAML_f5 * hypsmoothE02;
            end
            TempdepE63 = Tempdep;
        end
        RDDR_t = TempdepE63;
        if (ASYMMOD != 0) begin
            _argR64_1_ = RDDRR;
            _argR64_2_ = TRDDR;
            _argR64_3_ = delTemp;
            _argR64_4_ = TEMPMOD;
            begin : TempdepE64
                real Tempdep;
                real PARAML_f5, PARAMT_f5, DELTEMP_f5, TEMPMOD_f5;

                PARAML_f5 = _argR64_1_;
                PARAMT_f5 = _argR64_2_;
                DELTEMP_f5 = _argR64_3_;
                TEMPMOD_f5 = _argR64_4_;
                if (TEMPMOD_f5 != 0) begin
                    _argR1_1_ = PARAMT_f5 * DELTEMP_f5;
                    _argR1_2_ = -PARAML_f5;
                    _argR1_3_ = 1e-06;
                    begin : hypmaxE01
                        real hypmax;
                        real x_f4, xmin_f4, c_f4;

                        x_f4 = _argR1_1_;
                        xmin_f4 = _argR1_2_;
                        c_f4 = _argR1_3_;
                        hypmax = xmin_f4 + 0.5 * (x_f4 - xmin_f4 - c_f4 + sqrt((x_f4 - xmin_f4 - c_f4) * (x_f4 - xmin_f4 - c_f4) - 4.0 * xmin_f4 * c_f4));
                        hypmaxE01 = hypmax;
                    end
                    Tempdep = PARAML_f5 + hypmaxE01;
                end
                else begin
                    _argR2_1_ = 1.0 + PARAMT_f5 * DELTEMP_f5 - 1e-06;
                    _argR2_2_ = 0.001;
                    begin : hypsmoothE02
                        real hypsmooth;
                        real x_f3, c_f3;

                        x_f3 = _argR2_1_;
                        c_f3 = _argR2_2_;
                        hypsmooth = 0.5 * (x_f3 + sqrt(x_f3 * x_f3 + 4.0 * c_f3 * c_f3));
                        hypsmoothE02 = hypsmooth;
                    end
                    Tempdep = PARAML_f5 * hypsmoothE02;
                end
                TempdepE64 = Tempdep;
            end
            RDDRR_t = TempdepE64;
        end
        _argR65_1_ = VSAT_i;
        _argR65_2_ = -AT_i;
        _argR65_3_ = delTemp;
        _argR65_4_ = TEMPMOD;
        begin : TempdepE65
            real Tempdep;
            real PARAML_f5, PARAMT_f5, DELTEMP_f5, TEMPMOD_f5;

            PARAML_f5 = _argR65_1_;
            PARAMT_f5 = _argR65_2_;
            DELTEMP_f5 = _argR65_3_;
            TEMPMOD_f5 = _argR65_4_;
            if (TEMPMOD_f5 != 0) begin
                _argR1_1_ = PARAMT_f5 * DELTEMP_f5;
                _argR1_2_ = -PARAML_f5;
                _argR1_3_ = 1e-06;
                begin : hypmaxE01
                    real hypmax;
                    real x_f4, xmin_f4, c_f4;

                    x_f4 = _argR1_1_;
                    xmin_f4 = _argR1_2_;
                    c_f4 = _argR1_3_;
                    hypmax = xmin_f4 + 0.5 * (x_f4 - xmin_f4 - c_f4 + sqrt((x_f4 - xmin_f4 - c_f4) * (x_f4 - xmin_f4 - c_f4) - 4.0 * xmin_f4 * c_f4));
                    hypmaxE01 = hypmax;
                end
                Tempdep = PARAML_f5 + hypmaxE01;
            end
            else begin
                _argR2_1_ = 1.0 + PARAMT_f5 * DELTEMP_f5 - 1e-06;
                _argR2_2_ = 0.001;
                begin : hypsmoothE02
                    real hypsmooth;
                    real x_f3, c_f3;

                    x_f3 = _argR2_1_;
                    c_f3 = _argR2_2_;
                    hypsmooth = 0.5 * (x_f3 + sqrt(x_f3 * x_f3 + 4.0 * c_f3 * c_f3));
                    hypsmoothE02 = hypsmooth;
                end
                Tempdep = PARAML_f5 * hypsmoothE02;
            end
            TempdepE65 = Tempdep;
        end
        VSAT_t = TempdepE65;
        if (VSAT_t < 1000) begin
            $strobe("Warning: VSAT(%f) = %e is less than 1K, setting it to 1K.",DevTemp,VSAT_t);
            VSAT_t = 1000;
        end
        if (ASYMMOD != 0) begin
            _argR66_1_ = VSATR_i;
            _argR66_2_ = -ATR_i;
            _argR66_3_ = delTemp;
            _argR66_4_ = TEMPMOD;
            begin : TempdepE66
                real Tempdep;
                real PARAML_f5, PARAMT_f5, DELTEMP_f5, TEMPMOD_f5;

                PARAML_f5 = _argR66_1_;
                PARAMT_f5 = _argR66_2_;
                DELTEMP_f5 = _argR66_3_;
                TEMPMOD_f5 = _argR66_4_;
                if (TEMPMOD_f5 != 0) begin
                    _argR1_1_ = PARAMT_f5 * DELTEMP_f5;
                    _argR1_2_ = -PARAML_f5;
                    _argR1_3_ = 1e-06;
                    begin : hypmaxE01
                        real hypmax;
                        real x_f4, xmin_f4, c_f4;

                        x_f4 = _argR1_1_;
                        xmin_f4 = _argR1_2_;
                        c_f4 = _argR1_3_;
                        hypmax = xmin_f4 + 0.5 * (x_f4 - xmin_f4 - c_f4 + sqrt((x_f4 - xmin_f4 - c_f4) * (x_f4 - xmin_f4 - c_f4) - 4.0 * xmin_f4 * c_f4));
                        hypmaxE01 = hypmax;
                    end
                    Tempdep = PARAML_f5 + hypmaxE01;
                end
                else begin
                    _argR2_1_ = 1.0 + PARAMT_f5 * DELTEMP_f5 - 1e-06;
                    _argR2_2_ = 0.001;
                    begin : hypsmoothE02
                        real hypsmooth;
                        real x_f3, c_f3;

                        x_f3 = _argR2_1_;
                        c_f3 = _argR2_2_;
                        hypsmooth = 0.5 * (x_f3 + sqrt(x_f3 * x_f3 + 4.0 * c_f3 * c_f3));
                        hypsmoothE02 = hypsmooth;
                    end
                    Tempdep = PARAML_f5 * hypsmoothE02;
                end
                TempdepE66 = Tempdep;
            end
            VSATR_t = TempdepE66;
            if (VSATR_t < 1000) begin
                $strobe("Warning: VSATR(%f) = %e is less than 1K, setting it to 1K.",DevTemp,VSATR_t);
                VSATR_t = 1000;
            end
        end
        _argR67_1_ = VSAT1_i;
        _argR67_2_ = -AT_i;
        _argR67_3_ = delTemp;
        _argR67_4_ = TEMPMOD;
        begin : TempdepE67
            real Tempdep;
            real PARAML_f5, PARAMT_f5, DELTEMP_f5, TEMPMOD_f5;

            PARAML_f5 = _argR67_1_;
            PARAMT_f5 = _argR67_2_;
            DELTEMP_f5 = _argR67_3_;
            TEMPMOD_f5 = _argR67_4_;
            if (TEMPMOD_f5 != 0) begin
                _argR1_1_ = PARAMT_f5 * DELTEMP_f5;
                _argR1_2_ = -PARAML_f5;
                _argR1_3_ = 1e-06;
                begin : hypmaxE01
                    real hypmax;
                    real x_f4, xmin_f4, c_f4;

                    x_f4 = _argR1_1_;
                    xmin_f4 = _argR1_2_;
                    c_f4 = _argR1_3_;
                    hypmax = xmin_f4 + 0.5 * (x_f4 - xmin_f4 - c_f4 + sqrt((x_f4 - xmin_f4 - c_f4) * (x_f4 - xmin_f4 - c_f4) - 4.0 * xmin_f4 * c_f4));
                    hypmaxE01 = hypmax;
                end
                Tempdep = PARAML_f5 + hypmaxE01;
            end
            else begin
                _argR2_1_ = 1.0 + PARAMT_f5 * DELTEMP_f5 - 1e-06;
                _argR2_2_ = 0.001;
                begin : hypsmoothE02
                    real hypsmooth;
                    real x_f3, c_f3;

                    x_f3 = _argR2_1_;
                    c_f3 = _argR2_2_;
                    hypsmooth = 0.5 * (x_f3 + sqrt(x_f3 * x_f3 + 4.0 * c_f3 * c_f3));
                    hypsmoothE02 = hypsmooth;
                end
                Tempdep = PARAML_f5 * hypsmoothE02;
            end
            TempdepE67 = Tempdep;
        end
        VSAT1_t = TempdepE67;
        if (VSAT1_t < 1000) begin
            $strobe("Warning: VSAT1(%f) = %e is less than 1K, setting it to 1K.",DevTemp,VSAT1_t);
            VSAT1_t = 1000;
        end
        if (ASYMMOD != 0) begin
            _argR68_1_ = VSAT1R_i;
            _argR68_2_ = -AT_i;
            _argR68_3_ = delTemp;
            _argR68_4_ = TEMPMOD;
            begin : TempdepE68
                real Tempdep;
                real PARAML_f5, PARAMT_f5, DELTEMP_f5, TEMPMOD_f5;

                PARAML_f5 = _argR68_1_;
                PARAMT_f5 = _argR68_2_;
                DELTEMP_f5 = _argR68_3_;
                TEMPMOD_f5 = _argR68_4_;
                if (TEMPMOD_f5 != 0) begin
                    _argR1_1_ = PARAMT_f5 * DELTEMP_f5;
                    _argR1_2_ = -PARAML_f5;
                    _argR1_3_ = 1e-06;
                    begin : hypmaxE01
                        real hypmax;
                        real x_f4, xmin_f4, c_f4;

                        x_f4 = _argR1_1_;
                        xmin_f4 = _argR1_2_;
                        c_f4 = _argR1_3_;
                        hypmax = xmin_f4 + 0.5 * (x_f4 - xmin_f4 - c_f4 + sqrt((x_f4 - xmin_f4 - c_f4) * (x_f4 - xmin_f4 - c_f4) - 4.0 * xmin_f4 * c_f4));
                        hypmaxE01 = hypmax;
                    end
                    Tempdep = PARAML_f5 + hypmaxE01;
                end
                else begin
                    _argR2_1_ = 1.0 + PARAMT_f5 * DELTEMP_f5 - 1e-06;
                    _argR2_2_ = 0.001;
                    begin : hypsmoothE02
                        real hypsmooth;
                        real x_f3, c_f3;

                        x_f3 = _argR2_1_;
                        c_f3 = _argR2_2_;
                        hypsmooth = 0.5 * (x_f3 + sqrt(x_f3 * x_f3 + 4.0 * c_f3 * c_f3));
                        hypsmoothE02 = hypsmooth;
                    end
                    Tempdep = PARAML_f5 * hypsmoothE02;
                end
                TempdepE68 = Tempdep;
            end
            VSAT1R_t = TempdepE68;
            if (VSAT1R_t < 1000) begin
                $strobe("Warning: VSAT1R(%f) = %e is less than 1K, setting it to 1K.",DevTemp,VSAT1R_t);
                VSAT1R_t = 1000;
            end
        end
        _argR69_1_ = VSATCV_i;
        _argR69_2_ = -ATCV_i;
        _argR69_3_ = delTemp;
        _argR69_4_ = TEMPMOD;
        begin : TempdepE69
            real Tempdep;
            real PARAML_f5, PARAMT_f5, DELTEMP_f5, TEMPMOD_f5;

            PARAML_f5 = _argR69_1_;
            PARAMT_f5 = _argR69_2_;
            DELTEMP_f5 = _argR69_3_;
            TEMPMOD_f5 = _argR69_4_;
            if (TEMPMOD_f5 != 0) begin
                _argR1_1_ = PARAMT_f5 * DELTEMP_f5;
                _argR1_2_ = -PARAML_f5;
                _argR1_3_ = 1e-06;
                begin : hypmaxE01
                    real hypmax;
                    real x_f4, xmin_f4, c_f4;

                    x_f4 = _argR1_1_;
                    xmin_f4 = _argR1_2_;
                    c_f4 = _argR1_3_;
                    hypmax = xmin_f4 + 0.5 * (x_f4 - xmin_f4 - c_f4 + sqrt((x_f4 - xmin_f4 - c_f4) * (x_f4 - xmin_f4 - c_f4) - 4.0 * xmin_f4 * c_f4));
                    hypmaxE01 = hypmax;
                end
                Tempdep = PARAML_f5 + hypmaxE01;
            end
            else begin
                _argR2_1_ = 1.0 + PARAMT_f5 * DELTEMP_f5 - 1e-06;
                _argR2_2_ = 0.001;
                begin : hypsmoothE02
                    real hypsmooth;
                    real x_f3, c_f3;

                    x_f3 = _argR2_1_;
                    c_f3 = _argR2_2_;
                    hypsmooth = 0.5 * (x_f3 + sqrt(x_f3 * x_f3 + 4.0 * c_f3 * c_f3));
                    hypsmoothE02 = hypsmooth;
                end
                Tempdep = PARAML_f5 * hypsmoothE02;
            end
            TempdepE69 = Tempdep;
        end
        VSATCV_t = TempdepE69;
        if (VSATCV_t < 1000) begin
            $strobe("Warning: VSATCV(%f) = %e is less than 1K, setting it to 1K.",DevTemp,VSATCV_t);
            VSATCV_t = 1000;
        end
        _argR70_1_ = MEXP_i * (1.0 + TMEXP * delTemp) - 2.0;
        _argR70_2_ = 0.001;
        begin : hypsmoothE70
            real hypsmooth;
            real x_f3, c_f3;

            x_f3 = _argR70_1_;
            c_f3 = _argR70_2_;
            hypsmooth = 0.5 * (x_f3 + sqrt(x_f3 * x_f3 + 4.0 * c_f3 * c_f3));
            hypsmoothE70 = hypsmooth;
        end
        MEXP_t = hypsmoothE70 + 2.0;
        if (ASYMMOD != 0) begin
            _argR71_1_ = MEXPR_i * (1.0 + TMEXPR * delTemp) - 2.0;
            _argR71_2_ = 0.001;
            begin : hypsmoothE71
                real hypsmooth;
                real x_f3, c_f3;

                x_f3 = _argR71_1_;
                c_f3 = _argR71_2_;
                hypsmooth = 0.5 * (x_f3 + sqrt(x_f3 * x_f3 + 4.0 * c_f3 * c_f3));
                hypsmoothE71 = hypsmooth;
            end
            MEXPR_t = hypsmoothE71 + 2.0;
        end
        _argR72_1_ = PTWG_i;
        _argR72_2_ = -PTWGT_i;
        _argR72_3_ = delTemp;
        _argR72_4_ = TEMPMOD;
        begin : TempdepE72
            real Tempdep;
            real PARAML_f5, PARAMT_f5, DELTEMP_f5, TEMPMOD_f5;

            PARAML_f5 = _argR72_1_;
            PARAMT_f5 = _argR72_2_;
            DELTEMP_f5 = _argR72_3_;
            TEMPMOD_f5 = _argR72_4_;
            if (TEMPMOD_f5 != 0) begin
                _argR1_1_ = PARAMT_f5 * DELTEMP_f5;
                _argR1_2_ = -PARAML_f5;
                _argR1_3_ = 1e-06;
                begin : hypmaxE01
                    real hypmax;
                    real x_f4, xmin_f4, c_f4;

                    x_f4 = _argR1_1_;
                    xmin_f4 = _argR1_2_;
                    c_f4 = _argR1_3_;
                    hypmax = xmin_f4 + 0.5 * (x_f4 - xmin_f4 - c_f4 + sqrt((x_f4 - xmin_f4 - c_f4) * (x_f4 - xmin_f4 - c_f4) - 4.0 * xmin_f4 * c_f4));
                    hypmaxE01 = hypmax;
                end
                Tempdep = PARAML_f5 + hypmaxE01;
            end
            else begin
                _argR2_1_ = 1.0 + PARAMT_f5 * DELTEMP_f5 - 1e-06;
                _argR2_2_ = 0.001;
                begin : hypsmoothE02
                    real hypsmooth;
                    real x_f3, c_f3;

                    x_f3 = _argR2_1_;
                    c_f3 = _argR2_2_;
                    hypsmooth = 0.5 * (x_f3 + sqrt(x_f3 * x_f3 + 4.0 * c_f3 * c_f3));
                    hypsmoothE02 = hypsmooth;
                end
                Tempdep = PARAML_f5 * hypsmoothE02;
            end
            TempdepE72 = Tempdep;
        end
        PTWG_t = TempdepE72;
        if (ASYMMOD != 0) begin
            _argR73_1_ = PTWGR_i;
            _argR73_2_ = -PTWGT_i;
            _argR73_3_ = delTemp;
            _argR73_4_ = TEMPMOD;
            begin : TempdepE73
                real Tempdep;
                real PARAML_f5, PARAMT_f5, DELTEMP_f5, TEMPMOD_f5;

                PARAML_f5 = _argR73_1_;
                PARAMT_f5 = _argR73_2_;
                DELTEMP_f5 = _argR73_3_;
                TEMPMOD_f5 = _argR73_4_;
                if (TEMPMOD_f5 != 0) begin
                    _argR1_1_ = PARAMT_f5 * DELTEMP_f5;
                    _argR1_2_ = -PARAML_f5;
                    _argR1_3_ = 1e-06;
                    begin : hypmaxE01
                        real hypmax;
                        real x_f4, xmin_f4, c_f4;

                        x_f4 = _argR1_1_;
                        xmin_f4 = _argR1_2_;
                        c_f4 = _argR1_3_;
                        hypmax = xmin_f4 + 0.5 * (x_f4 - xmin_f4 - c_f4 + sqrt((x_f4 - xmin_f4 - c_f4) * (x_f4 - xmin_f4 - c_f4) - 4.0 * xmin_f4 * c_f4));
                        hypmaxE01 = hypmax;
                    end
                    Tempdep = PARAML_f5 + hypmaxE01;
                end
                else begin
                    _argR2_1_ = 1.0 + PARAMT_f5 * DELTEMP_f5 - 1e-06;
                    _argR2_2_ = 0.001;
                    begin : hypsmoothE02
                        real hypsmooth;
                        real x_f3, c_f3;

                        x_f3 = _argR2_1_;
                        c_f3 = _argR2_2_;
                        hypsmooth = 0.5 * (x_f3 + sqrt(x_f3 * x_f3 + 4.0 * c_f3 * c_f3));
                        hypsmoothE02 = hypsmooth;
                    end
                    Tempdep = PARAML_f5 * hypsmoothE02;
                end
                TempdepE73 = Tempdep;
            end
            PTWGR_t = TempdepE73;
        end
        dvth_temp = (KT1_i + KT1L / Leff) * (TRatio - 1.0);
        BETA0_t = BETA0_i * pow(TRatio,IIT_i);
        _argR74_1_ = 1.0 + TII_i * (TRatio - 1.0) - 0.01;
        _argR74_2_ = 0.001;
        begin : hypsmoothE74
            real hypsmooth;
            real x_f3, c_f3;

            x_f3 = _argR74_1_;
            c_f3 = _argR74_2_;
            hypsmooth = 0.5 * (x_f3 + sqrt(x_f3 * x_f3 + 4.0 * c_f3 * c_f3));
            hypsmoothE74 = hypsmooth;
        end
        SII0_t = SII0_i * (hypsmoothE74 + 0.01);
        K0_t = K0_i + K01_i * delTemp;
        _argR75_1_ = K0SI1_i * delTemp;
        _argR75_2_ = -K0SI_i;
        _argR75_3_ = 1e-06;
        begin : hypmaxE75
            real hypmax;
            real x_f4, xmin_f4, c_f4;

            x_f4 = _argR75_1_;
            xmin_f4 = _argR75_2_;
            c_f4 = _argR75_3_;
            hypmax = xmin_f4 + 0.5 * (x_f4 - xmin_f4 - c_f4 + sqrt((x_f4 - xmin_f4 - c_f4) * (x_f4 - xmin_f4 - c_f4) - 4.0 * xmin_f4 * c_f4));
            hypmaxE75 = hypmax;
        end
        K0SI_t = K0SI_i + hypmaxE75;
        _argR76_1_ = K2SI1_i * delTemp;
        _argR76_2_ = -K2SI_i;
        _argR76_3_ = 1e-06;
        begin : hypmaxE76
            real hypmax;
            real x_f4, xmin_f4, c_f4;

            x_f4 = _argR76_1_;
            xmin_f4 = _argR76_2_;
            c_f4 = _argR76_3_;
            hypmax = xmin_f4 + 0.5 * (x_f4 - xmin_f4 - c_f4 + sqrt((x_f4 - xmin_f4 - c_f4) * (x_f4 - xmin_f4 - c_f4) - 4.0 * xmin_f4 * c_f4));
            hypmaxE76 = hypmax;
        end
        K2SI_t = K2SI_i + hypmaxE76;
        _argR77_1_ = K11_i * delTemp;
        _argR77_2_ = -K1_i;
        _argR77_3_ = 1e-06;
        begin : hypmaxE77
            real hypmax;
            real x_f4, xmin_f4, c_f4;

            x_f4 = _argR77_1_;
            xmin_f4 = _argR77_2_;
            c_f4 = _argR77_3_;
            hypmax = xmin_f4 + 0.5 * (x_f4 - xmin_f4 - c_f4 + sqrt((x_f4 - xmin_f4 - c_f4) * (x_f4 - xmin_f4 - c_f4) - 4.0 * xmin_f4 * c_f4));
            hypmaxE77 = hypmax;
        end
        K1_t = K1_i + hypmaxE77;
        K2SAT_t = K2SAT_i + K2SAT1_i * delTemp;
        A1_t = A1_i + A11_i * delTemp;
        A2_t = A2_i + A21_i * delTemp;
        _argR78_1_ = K21_i * delTemp;
        _argR78_2_ = -K2_i;
        _argR78_3_ = 1e-06;
        begin : hypmaxE78
            real hypmax;
            real x_f4, xmin_f4, c_f4;

            x_f4 = _argR78_1_;
            xmin_f4 = _argR78_2_;
            c_f4 = _argR78_3_;
            hypmax = xmin_f4 + 0.5 * (x_f4 - xmin_f4 - c_f4 + sqrt((x_f4 - xmin_f4 - c_f4) * (x_f4 - xmin_f4 - c_f4) - 4.0 * xmin_f4 * c_f4));
            hypmaxE78 = hypmax;
        end
        K2_t = K2_i + hypmaxE78;
        K0SISAT_t = K0SISAT_i + K0SISAT1_i * delTemp;
        K2SISAT_t = K2SISAT_i + K2SISAT1_i * delTemp;
        _argR79_1_ = AIGBINV1_i * delTemp;
        _argR79_2_ = -AIGBINV_i;
        _argR79_3_ = 1e-06;
        begin : hypmaxE79
            real hypmax;
            real x_f4, xmin_f4, c_f4;

            x_f4 = _argR79_1_;
            xmin_f4 = _argR79_2_;
            c_f4 = _argR79_3_;
            hypmax = xmin_f4 + 0.5 * (x_f4 - xmin_f4 - c_f4 + sqrt((x_f4 - xmin_f4 - c_f4) * (x_f4 - xmin_f4 - c_f4) - 4.0 * xmin_f4 * c_f4));
            hypmaxE79 = hypmax;
        end
        AIGBINV_t = AIGBINV_i + hypmaxE79;
        _argR80_1_ = AIGBACC1_i * delTemp;
        _argR80_2_ = -AIGBACC_i;
        _argR80_3_ = 1e-06;
        begin : hypmaxE80
            real hypmax;
            real x_f4, xmin_f4, c_f4;

            x_f4 = _argR80_1_;
            xmin_f4 = _argR80_2_;
            c_f4 = _argR80_3_;
            hypmax = xmin_f4 + 0.5 * (x_f4 - xmin_f4 - c_f4 + sqrt((x_f4 - xmin_f4 - c_f4) * (x_f4 - xmin_f4 - c_f4) - 4.0 * xmin_f4 * c_f4));
            hypmaxE80 = hypmax;
        end
        AIGBACC_t = AIGBACC_i + hypmaxE80;
        _argR81_1_ = AIGC1_i * delTemp;
        _argR81_2_ = -AIGC_i;
        _argR81_3_ = 1e-06;
        begin : hypmaxE81
            real hypmax;
            real x_f4, xmin_f4, c_f4;

            x_f4 = _argR81_1_;
            xmin_f4 = _argR81_2_;
            c_f4 = _argR81_3_;
            hypmax = xmin_f4 + 0.5 * (x_f4 - xmin_f4 - c_f4 + sqrt((x_f4 - xmin_f4 - c_f4) * (x_f4 - xmin_f4 - c_f4) - 4.0 * xmin_f4 * c_f4));
            hypmaxE81 = hypmax;
        end
        AIGC_t = AIGC_i + hypmaxE81;
        _argR82_1_ = AIGS1_i * delTemp;
        _argR82_2_ = -AIGS_i;
        _argR82_3_ = 1e-06;
        begin : hypmaxE82
            real hypmax;
            real x_f4, xmin_f4, c_f4;

            x_f4 = _argR82_1_;
            xmin_f4 = _argR82_2_;
            c_f4 = _argR82_3_;
            hypmax = xmin_f4 + 0.5 * (x_f4 - xmin_f4 - c_f4 + sqrt((x_f4 - xmin_f4 - c_f4) * (x_f4 - xmin_f4 - c_f4) - 4.0 * xmin_f4 * c_f4));
            hypmaxE82 = hypmax;
        end
        AIGS_t = AIGS_i + hypmaxE82;
        _argR83_1_ = AIGD1_i * delTemp;
        _argR83_2_ = -AIGD_i;
        _argR83_3_ = 1e-06;
        begin : hypmaxE83
            real hypmax;
            real x_f4, xmin_f4, c_f4;

            x_f4 = _argR83_1_;
            xmin_f4 = _argR83_2_;
            c_f4 = _argR83_3_;
            hypmax = xmin_f4 + 0.5 * (x_f4 - xmin_f4 - c_f4 + sqrt((x_f4 - xmin_f4 - c_f4) * (x_f4 - xmin_f4 - c_f4) - 4.0 * xmin_f4 * c_f4));
            hypmaxE83 = hypmax;
        end
        AIGD_t = AIGD_i + hypmaxE83;
        _argR84_1_ = 1.0 + TGIDL_i * delTemp - 1e-06;
        _argR84_2_ = 0.001;
        begin : hypsmoothE84
            real hypsmooth;
            real x_f3, c_f3;

            x_f3 = _argR84_1_;
            c_f3 = _argR84_2_;
            hypsmooth = 0.5 * (x_f3 + sqrt(x_f3 * x_f3 + 4.0 * c_f3 * c_f3));
            hypsmoothE84 = hypsmooth;
        end
        BGIDL_t = BGIDL_i * hypsmoothE84;
        _argR85_1_ = 1.0 + TGIDL_i * delTemp - 1e-06;
        _argR85_2_ = 0.001;
        begin : hypsmoothE85
            real hypsmooth;
            real x_f3, c_f3;

            x_f3 = _argR85_1_;
            c_f3 = _argR85_2_;
            hypsmooth = 0.5 * (x_f3 + sqrt(x_f3 * x_f3 + 4.0 * c_f3 * c_f3));
            hypsmoothE85 = hypsmooth;
        end
        BGISL_t = BGISL_i * hypsmoothE85;
        _argR86_1_ = ALPHA01 * delTemp;
        _argR86_2_ = -ALPHA0_i;
        _argR86_3_ = 1e-06;
        begin : hypmaxE86
            real hypmax;
            real x_f4, xmin_f4, c_f4;

            x_f4 = _argR86_1_;
            xmin_f4 = _argR86_2_;
            c_f4 = _argR86_3_;
            hypmax = xmin_f4 + 0.5 * (x_f4 - xmin_f4 - c_f4 + sqrt((x_f4 - xmin_f4 - c_f4) * (x_f4 - xmin_f4 - c_f4) - 4.0 * xmin_f4 * c_f4));
            hypmaxE86 = hypmax;
        end
        ALPHA0_t = ALPHA0_i + hypmaxE86;
        _argR87_1_ = ALPHA11 * delTemp;
        _argR87_2_ = -ALPHA1_i;
        _argR87_3_ = 1e-06;
        begin : hypmaxE87
            real hypmax;
            real x_f4, xmin_f4, c_f4;

            x_f4 = _argR87_1_;
            xmin_f4 = _argR87_2_;
            c_f4 = _argR87_3_;
            hypmax = xmin_f4 + 0.5 * (x_f4 - xmin_f4 - c_f4 + sqrt((x_f4 - xmin_f4 - c_f4) * (x_f4 - xmin_f4 - c_f4) - 4.0 * xmin_f4 * c_f4));
            hypmaxE87 = hypmax;
        end
        ALPHA1_t = ALPHA1_i + hypmaxE87;
        _argR88_1_ = ALPHAII01 * delTemp;
        _argR88_2_ = -ALPHAII0_i;
        _argR88_3_ = 1e-25;
        begin : hypmaxE88
            real hypmax;
            real x_f4, xmin_f4, c_f4;

            x_f4 = _argR88_1_;
            xmin_f4 = _argR88_2_;
            c_f4 = _argR88_3_;
            hypmax = xmin_f4 + 0.5 * (x_f4 - xmin_f4 - c_f4 + sqrt((x_f4 - xmin_f4 - c_f4) * (x_f4 - xmin_f4 - c_f4) - 4.0 * xmin_f4 * c_f4));
            hypmaxE88 = hypmax;
        end
        ALPHAII0_t = ALPHAII0_i + hypmaxE88;
        _argR89_1_ = ALPHAII11 * delTemp;
        _argR89_2_ = -ALPHAII1_i;
        _argR89_3_ = 9.9999999999999995e-21;
        begin : hypmaxE89
            real hypmax;
            real x_f4, xmin_f4, c_f4;

            x_f4 = _argR89_1_;
            xmin_f4 = _argR89_2_;
            c_f4 = _argR89_3_;
            hypmax = xmin_f4 + 0.5 * (x_f4 - xmin_f4 - c_f4 + sqrt((x_f4 - xmin_f4 - c_f4) * (x_f4 - xmin_f4 - c_f4) - 4.0 * xmin_f4 * c_f4));
            hypmaxE89 = hypmax;
        end
        ALPHAII1_t = ALPHAII1_i + hypmaxE89;
        _argR90_1_ = TRatio;
        begin : llnE90
            real lln;
            real x_f2;

            x_f2 = _argR90_1_;
            lln = ln(max(x_f2,9.9999999999999996e-39));
            llnE90 = lln;
        end
        _argR91_1_ = IGT_i * llnE90;
        begin : lexpE91
            real lexp;
            real x_f1;

            x_f1 = _argR91_1_;
            if (x_f1 > 80.0) begin
                lexp = 5.540622384000e+34 * (1.0 + x_f1 - 80.0);
            end
            else if (x_f1 < -80.0) begin
                lexp = 1.804851387e-35;
            end
            else begin
                lexp = exp(x_f1);
            end
            lexpE91 = lexp;
        end
        igtemp = lexpE91;
        igsd_mult = igsd_mult0 * igtemp;
        if (BULKMOD != 0) begin
            _argR92_1_ = CJS;
            _argR92_2_ = TCJ;
            _argR92_3_ = delTemp;
            _argR92_4_ = TEMPMOD;
            begin : TempdepE92
                real Tempdep;
                real PARAML_f5, PARAMT_f5, DELTEMP_f5, TEMPMOD_f5;

                PARAML_f5 = _argR92_1_;
                PARAMT_f5 = _argR92_2_;
                DELTEMP_f5 = _argR92_3_;
                TEMPMOD_f5 = _argR92_4_;
                if (TEMPMOD_f5 != 0) begin
                    _argR1_1_ = PARAMT_f5 * DELTEMP_f5;
                    _argR1_2_ = -PARAML_f5;
                    _argR1_3_ = 1e-06;
                    begin : hypmaxE01
                        real hypmax;
                        real x_f4, xmin_f4, c_f4;

                        x_f4 = _argR1_1_;
                        xmin_f4 = _argR1_2_;
                        c_f4 = _argR1_3_;
                        hypmax = xmin_f4 + 0.5 * (x_f4 - xmin_f4 - c_f4 + sqrt((x_f4 - xmin_f4 - c_f4) * (x_f4 - xmin_f4 - c_f4) - 4.0 * xmin_f4 * c_f4));
                        hypmaxE01 = hypmax;
                    end
                    Tempdep = PARAML_f5 + hypmaxE01;
                end
                else begin
                    _argR2_1_ = 1.0 + PARAMT_f5 * DELTEMP_f5 - 1e-06;
                    _argR2_2_ = 0.001;
                    begin : hypsmoothE02
                        real hypsmooth;
                        real x_f3, c_f3;

                        x_f3 = _argR2_1_;
                        c_f3 = _argR2_2_;
                        hypsmooth = 0.5 * (x_f3 + sqrt(x_f3 * x_f3 + 4.0 * c_f3 * c_f3));
                        hypsmoothE02 = hypsmooth;
                    end
                    Tempdep = PARAML_f5 * hypsmoothE02;
                end
                TempdepE92 = Tempdep;
            end
            CJS_t = TempdepE92;
            _argR93_1_ = CJD;
            _argR93_2_ = TCJ;
            _argR93_3_ = delTemp;
            _argR93_4_ = TEMPMOD;
            begin : TempdepE93
                real Tempdep;
                real PARAML_f5, PARAMT_f5, DELTEMP_f5, TEMPMOD_f5;

                PARAML_f5 = _argR93_1_;
                PARAMT_f5 = _argR93_2_;
                DELTEMP_f5 = _argR93_3_;
                TEMPMOD_f5 = _argR93_4_;
                if (TEMPMOD_f5 != 0) begin
                    _argR1_1_ = PARAMT_f5 * DELTEMP_f5;
                    _argR1_2_ = -PARAML_f5;
                    _argR1_3_ = 1e-06;
                    begin : hypmaxE01
                        real hypmax;
                        real x_f4, xmin_f4, c_f4;

                        x_f4 = _argR1_1_;
                        xmin_f4 = _argR1_2_;
                        c_f4 = _argR1_3_;
                        hypmax = xmin_f4 + 0.5 * (x_f4 - xmin_f4 - c_f4 + sqrt((x_f4 - xmin_f4 - c_f4) * (x_f4 - xmin_f4 - c_f4) - 4.0 * xmin_f4 * c_f4));
                        hypmaxE01 = hypmax;
                    end
                    Tempdep = PARAML_f5 + hypmaxE01;
                end
                else begin
                    _argR2_1_ = 1.0 + PARAMT_f5 * DELTEMP_f5 - 1e-06;
                    _argR2_2_ = 0.001;
                    begin : hypsmoothE02
                        real hypsmooth;
                        real x_f3, c_f3;

                        x_f3 = _argR2_1_;
                        c_f3 = _argR2_2_;
                        hypsmooth = 0.5 * (x_f3 + sqrt(x_f3 * x_f3 + 4.0 * c_f3 * c_f3));
                        hypsmoothE02 = hypsmooth;
                    end
                    Tempdep = PARAML_f5 * hypsmoothE02;
                end
                TempdepE93 = Tempdep;
            end
            CJD_t = TempdepE93;
            _argR94_1_ = CJSWS;
            _argR94_2_ = TCJSW;
            _argR94_3_ = delTemp;
            _argR94_4_ = TEMPMOD;
            begin : TempdepE94
                real Tempdep;
                real PARAML_f5, PARAMT_f5, DELTEMP_f5, TEMPMOD_f5;

                PARAML_f5 = _argR94_1_;
                PARAMT_f5 = _argR94_2_;
                DELTEMP_f5 = _argR94_3_;
                TEMPMOD_f5 = _argR94_4_;
                if (TEMPMOD_f5 != 0) begin
                    _argR1_1_ = PARAMT_f5 * DELTEMP_f5;
                    _argR1_2_ = -PARAML_f5;
                    _argR1_3_ = 1e-06;
                    begin : hypmaxE01
                        real hypmax;
                        real x_f4, xmin_f4, c_f4;

                        x_f4 = _argR1_1_;
                        xmin_f4 = _argR1_2_;
                        c_f4 = _argR1_3_;
                        hypmax = xmin_f4 + 0.5 * (x_f4 - xmin_f4 - c_f4 + sqrt((x_f4 - xmin_f4 - c_f4) * (x_f4 - xmin_f4 - c_f4) - 4.0 * xmin_f4 * c_f4));
                        hypmaxE01 = hypmax;
                    end
                    Tempdep = PARAML_f5 + hypmaxE01;
                end
                else begin
                    _argR2_1_ = 1.0 + PARAMT_f5 * DELTEMP_f5 - 1e-06;
                    _argR2_2_ = 0.001;
                    begin : hypsmoothE02
                        real hypsmooth;
                        real x_f3, c_f3;

                        x_f3 = _argR2_1_;
                        c_f3 = _argR2_2_;
                        hypsmooth = 0.5 * (x_f3 + sqrt(x_f3 * x_f3 + 4.0 * c_f3 * c_f3));
                        hypsmoothE02 = hypsmooth;
                    end
                    Tempdep = PARAML_f5 * hypsmoothE02;
                end
                TempdepE94 = Tempdep;
            end
            CJSWS_t = TempdepE94;
            _argR95_1_ = CJSWD;
            _argR95_2_ = TCJSW;
            _argR95_3_ = delTemp;
            _argR95_4_ = TEMPMOD;
            begin : TempdepE95
                real Tempdep;
                real PARAML_f5, PARAMT_f5, DELTEMP_f5, TEMPMOD_f5;

                PARAML_f5 = _argR95_1_;
                PARAMT_f5 = _argR95_2_;
                DELTEMP_f5 = _argR95_3_;
                TEMPMOD_f5 = _argR95_4_;
                if (TEMPMOD_f5 != 0) begin
                    _argR1_1_ = PARAMT_f5 * DELTEMP_f5;
                    _argR1_2_ = -PARAML_f5;
                    _argR1_3_ = 1e-06;
                    begin : hypmaxE01
                        real hypmax;
                        real x_f4, xmin_f4, c_f4;

                        x_f4 = _argR1_1_;
                        xmin_f4 = _argR1_2_;
                        c_f4 = _argR1_3_;
                        hypmax = xmin_f4 + 0.5 * (x_f4 - xmin_f4 - c_f4 + sqrt((x_f4 - xmin_f4 - c_f4) * (x_f4 - xmin_f4 - c_f4) - 4.0 * xmin_f4 * c_f4));
                        hypmaxE01 = hypmax;
                    end
                    Tempdep = PARAML_f5 + hypmaxE01;
                end
                else begin
                    _argR2_1_ = 1.0 + PARAMT_f5 * DELTEMP_f5 - 1e-06;
                    _argR2_2_ = 0.001;
                    begin : hypsmoothE02
                        real hypsmooth;
                        real x_f3, c_f3;

                        x_f3 = _argR2_1_;
                        c_f3 = _argR2_2_;
                        hypsmooth = 0.5 * (x_f3 + sqrt(x_f3 * x_f3 + 4.0 * c_f3 * c_f3));
                        hypsmoothE02 = hypsmooth;
                    end
                    Tempdep = PARAML_f5 * hypsmoothE02;
                end
                TempdepE95 = Tempdep;
            end
            CJSWD_t = TempdepE95;
            _argR96_1_ = CJSWGS;
            _argR96_2_ = TCJSWG;
            _argR96_3_ = delTemp;
            _argR96_4_ = TEMPMOD;
            begin : TempdepE96
                real Tempdep;
                real PARAML_f5, PARAMT_f5, DELTEMP_f5, TEMPMOD_f5;

                PARAML_f5 = _argR96_1_;
                PARAMT_f5 = _argR96_2_;
                DELTEMP_f5 = _argR96_3_;
                TEMPMOD_f5 = _argR96_4_;
                if (TEMPMOD_f5 != 0) begin
                    _argR1_1_ = PARAMT_f5 * DELTEMP_f5;
                    _argR1_2_ = -PARAML_f5;
                    _argR1_3_ = 1e-06;
                    begin : hypmaxE01
                        real hypmax;
                        real x_f4, xmin_f4, c_f4;

                        x_f4 = _argR1_1_;
                        xmin_f4 = _argR1_2_;
                        c_f4 = _argR1_3_;
                        hypmax = xmin_f4 + 0.5 * (x_f4 - xmin_f4 - c_f4 + sqrt((x_f4 - xmin_f4 - c_f4) * (x_f4 - xmin_f4 - c_f4) - 4.0 * xmin_f4 * c_f4));
                        hypmaxE01 = hypmax;
                    end
                    Tempdep = PARAML_f5 + hypmaxE01;
                end
                else begin
                    _argR2_1_ = 1.0 + PARAMT_f5 * DELTEMP_f5 - 1e-06;
                    _argR2_2_ = 0.001;
                    begin : hypsmoothE02
                        real hypsmooth;
                        real x_f3, c_f3;

                        x_f3 = _argR2_1_;
                        c_f3 = _argR2_2_;
                        hypsmooth = 0.5 * (x_f3 + sqrt(x_f3 * x_f3 + 4.0 * c_f3 * c_f3));
                        hypsmoothE02 = hypsmooth;
                    end
                    Tempdep = PARAML_f5 * hypsmoothE02;
                end
                TempdepE96 = Tempdep;
            end
            CJSWGS_t = TempdepE96;
            _argR97_1_ = CJSWGD;
            _argR97_2_ = TCJSWG;
            _argR97_3_ = delTemp;
            _argR97_4_ = TEMPMOD;
            begin : TempdepE97
                real Tempdep;
                real PARAML_f5, PARAMT_f5, DELTEMP_f5, TEMPMOD_f5;

                PARAML_f5 = _argR97_1_;
                PARAMT_f5 = _argR97_2_;
                DELTEMP_f5 = _argR97_3_;
                TEMPMOD_f5 = _argR97_4_;
                if (TEMPMOD_f5 != 0) begin
                    _argR1_1_ = PARAMT_f5 * DELTEMP_f5;
                    _argR1_2_ = -PARAML_f5;
                    _argR1_3_ = 1e-06;
                    begin : hypmaxE01
                        real hypmax;
                        real x_f4, xmin_f4, c_f4;

                        x_f4 = _argR1_1_;
                        xmin_f4 = _argR1_2_;
                        c_f4 = _argR1_3_;
                        hypmax = xmin_f4 + 0.5 * (x_f4 - xmin_f4 - c_f4 + sqrt((x_f4 - xmin_f4 - c_f4) * (x_f4 - xmin_f4 - c_f4) - 4.0 * xmin_f4 * c_f4));
                        hypmaxE01 = hypmax;
                    end
                    Tempdep = PARAML_f5 + hypmaxE01;
                end
                else begin
                    _argR2_1_ = 1.0 + PARAMT_f5 * DELTEMP_f5 - 1e-06;
                    _argR2_2_ = 0.001;
                    begin : hypsmoothE02
                        real hypsmooth;
                        real x_f3, c_f3;

                        x_f3 = _argR2_1_;
                        c_f3 = _argR2_2_;
                        hypsmooth = 0.5 * (x_f3 + sqrt(x_f3 * x_f3 + 4.0 * c_f3 * c_f3));
                        hypsmoothE02 = hypsmooth;
                    end
                    Tempdep = PARAML_f5 * hypsmoothE02;
                end
                TempdepE97 = Tempdep;
            end
            CJSWGD_t = TempdepE97;
            _argR98_1_ = PBS - TPB * delTemp - 0.01;
            _argR98_2_ = 0.001;
            begin : hypsmoothE98
                real hypsmooth;
                real x_f3, c_f3;

                x_f3 = _argR98_1_;
                c_f3 = _argR98_2_;
                hypsmooth = 0.5 * (x_f3 + sqrt(x_f3 * x_f3 + 4.0 * c_f3 * c_f3));
                hypsmoothE98 = hypsmooth;
            end
            PBS_t = hypsmoothE98 + 0.01;
            _argR99_1_ = PBD - TPB * delTemp - 0.01;
            _argR99_2_ = 0.001;
            begin : hypsmoothE99
                real hypsmooth;
                real x_f3, c_f3;

                x_f3 = _argR99_1_;
                c_f3 = _argR99_2_;
                hypsmooth = 0.5 * (x_f3 + sqrt(x_f3 * x_f3 + 4.0 * c_f3 * c_f3));
                hypsmoothE99 = hypsmooth;
            end
            PBD_t = hypsmoothE99 + 0.01;
            _argR100_1_ = PBSWS - TPBSW * delTemp - 0.01;
            _argR100_2_ = 0.001;
            begin : hypsmoothE100
                real hypsmooth;
                real x_f3, c_f3;

                x_f3 = _argR100_1_;
                c_f3 = _argR100_2_;
                hypsmooth = 0.5 * (x_f3 + sqrt(x_f3 * x_f3 + 4.0 * c_f3 * c_f3));
                hypsmoothE100 = hypsmooth;
            end
            PBSWS_t = hypsmoothE100 + 0.01;
            _argR101_1_ = PBSWD - TPBSW * delTemp - 0.01;
            _argR101_2_ = 0.001;
            begin : hypsmoothE101
                real hypsmooth;
                real x_f3, c_f3;

                x_f3 = _argR101_1_;
                c_f3 = _argR101_2_;
                hypsmooth = 0.5 * (x_f3 + sqrt(x_f3 * x_f3 + 4.0 * c_f3 * c_f3));
                hypsmoothE101 = hypsmooth;
            end
            PBSWD_t = hypsmoothE101 + 0.01;
            _argR102_1_ = PBSWGS - TPBSWG * delTemp - 0.01;
            _argR102_2_ = 0.001;
            begin : hypsmoothE102
                real hypsmooth;
                real x_f3, c_f3;

                x_f3 = _argR102_1_;
                c_f3 = _argR102_2_;
                hypsmooth = 0.5 * (x_f3 + sqrt(x_f3 * x_f3 + 4.0 * c_f3 * c_f3));
                hypsmoothE102 = hypsmooth;
            end
            PBSWGS_t = hypsmoothE102 + 0.01;
            _argR103_1_ = PBSWGD - TPBSWG * delTemp - 0.01;
            _argR103_2_ = 0.001;
            begin : hypsmoothE103
                real hypsmooth;
                real x_f3, c_f3;

                x_f3 = _argR103_1_;
                c_f3 = _argR103_2_;
                hypsmooth = 0.5 * (x_f3 + sqrt(x_f3 * x_f3 + 4.0 * c_f3 * c_f3));
                hypsmoothE103 = hypsmooth;
            end
            PBSWGD_t = hypsmoothE103 + 0.01;
            T0 = Eg0 / Vtm0 - Eg / Vtm;
            _argR104_1_ = TRatio;
            begin : llnE104
                real lln;
                real x_f2;

                x_f2 = _argR104_1_;
                lln = ln(max(x_f2,9.9999999999999996e-39));
                llnE104 = lln;
            end
            T1 = llnE104;
            _argR105_1_ = (T0 + XTIS * T1) / NJS;
            begin : lexpE105
                real lexp;
                real x_f1;

                x_f1 = _argR105_1_;
                if (x_f1 > 80.0) begin
                    lexp = 5.540622384000e+34 * (1.0 + x_f1 - 80.0);
                end
                else if (x_f1 < -80.0) begin
                    lexp = 1.804851387e-35;
                end
                else begin
                    lexp = exp(x_f1);
                end
                lexpE105 = lexp;
            end
            T3 = lexpE105;
            JSS_t = JSS * T3;
            JSWS_t = JSWS * T3;
            JSWGS_t = JSWGS * T3;
            _argR106_1_ = (T0 + XTID * T1) / NJD;
            begin : lexpE106
                real lexp;
                real x_f1;

                x_f1 = _argR106_1_;
                if (x_f1 > 80.0) begin
                    lexp = 5.540622384000e+34 * (1.0 + x_f1 - 80.0);
                end
                else if (x_f1 < -80.0) begin
                    lexp = 1.804851387e-35;
                end
                else begin
                    lexp = exp(x_f1);
                end
                lexpE106 = lexp;
            end
            T3 = lexpE106;
            JSD_t = JSD * T3;
            JSWD_t = JSWD * T3;
            JSWGD_t = JSWGD * T3;
            _argR107_1_ = Eg0 * XTSS * (TRatio - 1.0) / Vtm;
            begin : lexpE107
                real lexp;
                real x_f1;

                x_f1 = _argR107_1_;
                if (x_f1 > 80.0) begin
                    lexp = 5.540622384000e+34 * (1.0 + x_f1 - 80.0);
                end
                else if (x_f1 < -80.0) begin
                    lexp = 1.804851387e-35;
                end
                else begin
                    lexp = exp(x_f1);
                end
                lexpE107 = lexp;
            end
            JTSS_t = JTSS * lexpE107;
            _argR108_1_ = Eg0 * XTSD * (TRatio - 1.0) / Vtm;
            begin : lexpE108
                real lexp;
                real x_f1;

                x_f1 = _argR108_1_;
                if (x_f1 > 80.0) begin
                    lexp = 5.540622384000e+34 * (1.0 + x_f1 - 80.0);
                end
                else if (x_f1 < -80.0) begin
                    lexp = 1.804851387e-35;
                end
                else begin
                    lexp = exp(x_f1);
                end
                lexpE108 = lexp;
            end
            JTSD_t = JTSD * lexpE108;
            _argR109_1_ = Eg0 * XTSSWS * (TRatio - 1.0) / Vtm;
            begin : lexpE109
                real lexp;
                real x_f1;

                x_f1 = _argR109_1_;
                if (x_f1 > 80.0) begin
                    lexp = 5.540622384000e+34 * (1.0 + x_f1 - 80.0);
                end
                else if (x_f1 < -80.0) begin
                    lexp = 1.804851387e-35;
                end
                else begin
                    lexp = exp(x_f1);
                end
                lexpE109 = lexp;
            end
            JTSSWS_t = JTSSWS * lexpE109;
            _argR110_1_ = Eg0 * XTSSWD * (TRatio - 1.0) / Vtm;
            begin : lexpE110
                real lexp;
                real x_f1;

                x_f1 = _argR110_1_;
                if (x_f1 > 80.0) begin
                    lexp = 5.540622384000e+34 * (1.0 + x_f1 - 80.0);
                end
                else if (x_f1 < -80.0) begin
                    lexp = 1.804851387e-35;
                end
                else begin
                    lexp = exp(x_f1);
                end
                lexpE110 = lexp;
            end
            JTSSWD_t = JTSSWD * lexpE110;
            _argR111_1_ = Eg0 * XTSSWGS * (TRatio - 1.0) / Vtm;
            begin : lexpE111
                real lexp;
                real x_f1;

                x_f1 = _argR111_1_;
                if (x_f1 > 80.0) begin
                    lexp = 5.540622384000e+34 * (1.0 + x_f1 - 80.0);
                end
                else if (x_f1 < -80.0) begin
                    lexp = 1.804851387e-35;
                end
                else begin
                    lexp = exp(x_f1);
                end
                lexpE111 = lexp;
            end
            JTSSWGS_t = JTSSWGS * (sqrt(JTWEFF / Weff0) + 1.0) * lexpE111;
            _argR112_1_ = Eg0 * XTSSWGD * (TRatio - 1.0) / Vtm;
            begin : lexpE112
                real lexp;
                real x_f1;

                x_f1 = _argR112_1_;
                if (x_f1 > 80.0) begin
                    lexp = 5.540622384000e+34 * (1.0 + x_f1 - 80.0);
                end
                else if (x_f1 < -80.0) begin
                    lexp = 1.804851387e-35;
                end
                else begin
                    lexp = exp(x_f1);
                end
                lexpE112 = lexp;
            end
            JTSSWGD_t = JTSSWGD * (sqrt(JTWEFF / Weff0) + 1.0) * lexpE112;
            _argR113_1_ = NJTS * (1.0 + TNJTS * (TRatio - 1.0)) - 0.01;
            _argR113_2_ = 0.001;
            begin : hypsmoothE113
                real hypsmooth;
                real x_f3, c_f3;

                x_f3 = _argR113_1_;
                c_f3 = _argR113_2_;
                hypsmooth = 0.5 * (x_f3 + sqrt(x_f3 * x_f3 + 4.0 * c_f3 * c_f3));
                hypsmoothE113 = hypsmooth;
            end
            NJTS_t = hypsmoothE113 + 0.01;
            _argR114_1_ = NJTSD * (1.0 + TNJTSD * (TRatio - 1.0)) - 0.01;
            _argR114_2_ = 0.001;
            begin : hypsmoothE114
                real hypsmooth;
                real x_f3, c_f3;

                x_f3 = _argR114_1_;
                c_f3 = _argR114_2_;
                hypsmooth = 0.5 * (x_f3 + sqrt(x_f3 * x_f3 + 4.0 * c_f3 * c_f3));
                hypsmoothE114 = hypsmooth;
            end
            NJTSD_t = hypsmoothE114 + 0.01;
            _argR115_1_ = NJTSSW * (1.0 + TNJTSSW * (TRatio - 1.0)) - 0.01;
            _argR115_2_ = 0.001;
            begin : hypsmoothE115
                real hypsmooth;
                real x_f3, c_f3;

                x_f3 = _argR115_1_;
                c_f3 = _argR115_2_;
                hypsmooth = 0.5 * (x_f3 + sqrt(x_f3 * x_f3 + 4.0 * c_f3 * c_f3));
                hypsmoothE115 = hypsmooth;
            end
            NJTSSW_t = hypsmoothE115 + 0.01;
            _argR116_1_ = NJTSSWD * (1.0 + TNJTSSWD * (TRatio - 1.0)) - 0.01;
            _argR116_2_ = 0.001;
            begin : hypsmoothE116
                real hypsmooth;
                real x_f3, c_f3;

                x_f3 = _argR116_1_;
                c_f3 = _argR116_2_;
                hypsmooth = 0.5 * (x_f3 + sqrt(x_f3 * x_f3 + 4.0 * c_f3 * c_f3));
                hypsmoothE116 = hypsmooth;
            end
            NJTSSWD_t = hypsmoothE116 + 0.01;
            _argR117_1_ = NJTSSWG * (1.0 + TNJTSSWG * (TRatio - 1.0)) - 0.01;
            _argR117_2_ = 0.001;
            begin : hypsmoothE117
                real hypsmooth;
                real x_f3, c_f3;

                x_f3 = _argR117_1_;
                c_f3 = _argR117_2_;
                hypsmooth = 0.5 * (x_f3 + sqrt(x_f3 * x_f3 + 4.0 * c_f3 * c_f3));
                hypsmoothE117 = hypsmooth;
            end
            NJTSSWG_t = hypsmoothE117 + 0.01;
            _argR118_1_ = NJTSSWGD * (1.0 + TNJTSSWGD * (TRatio - 1.0)) - 0.01;
            _argR118_2_ = 0.001;
            begin : hypsmoothE118
                real hypsmooth;
                real x_f3, c_f3;

                x_f3 = _argR118_1_;
                c_f3 = _argR118_2_;
                hypsmooth = 0.5 * (x_f3 + sqrt(x_f3 * x_f3 + 4.0 * c_f3 * c_f3));
                hypsmoothE118 = hypsmooth;
            end
            NJTSSWGD_t = hypsmoothE118 + 0.01;
        end
        if (!$param_given(VFBSD)) begin
            if (NGATE > 0.0) begin
                _argR119_1_ = NGATE / ni;
                begin : llnE119
                    real lln;
                    real x_f2;

                    x_f2 = _argR119_1_;
                    lln = ln(max(x_f2,9.9999999999999996e-39));
                    llnE119 = lln;
                end
                _argR120_1_ = 0.5 * Eg - Vtm * llnE119;
                _argR120_2_ = 0.0001;
                begin : hypsmoothE120
                    real hypsmooth;
                    real x_f3, c_f3;

                    x_f3 = _argR120_1_;
                    c_f3 = _argR120_2_;
                    hypsmooth = 0.5 * (x_f3 + sqrt(x_f3 * x_f3 + 4.0 * c_f3 * c_f3));
                    hypsmoothE120 = hypsmooth;
                end
                _argR121_1_ = NSD / ni;
                begin : llnE121
                    real lln;
                    real x_f2;

                    x_f2 = _argR121_1_;
                    lln = ln(max(x_f2,9.9999999999999996e-39));
                    llnE121 = lln;
                end
                _argR122_1_ = 0.5 * Eg - Vtm * llnE121;
                _argR122_2_ = 0.0001;
                begin : hypsmoothE122
                    real hypsmooth;
                    real x_f3, c_f3;

                    x_f3 = _argR122_1_;
                    c_f3 = _argR122_2_;
                    hypsmooth = 0.5 * (x_f3 + sqrt(x_f3 * x_f3 + 4.0 * c_f3 * c_f3));
                    hypsmoothE122 = hypsmooth;
                end
                vfbsd = devsign * (hypsmoothE120 - (0.5 * Eg - devsign * (0.5 * Eg - hypsmoothE122)));
            end
            else begin
                _argR123_1_ = NSD / ni;
                begin : llnE123
                    real lln;
                    real x_f2;

                    x_f2 = _argR123_1_;
                    lln = ln(max(x_f2,9.9999999999999996e-39));
                    llnE123 = lln;
                end
                _argR124_1_ = 0.5 * Eg - Vtm * llnE123;
                _argR124_2_ = 0.0001;
                begin : hypsmoothE124
                    real hypsmooth;
                    real x_f3, c_f3;

                    x_f3 = _argR124_1_;
                    c_f3 = _argR124_2_;
                    hypsmooth = 0.5 * (x_f3 + sqrt(x_f3 * x_f3 + 4.0 * c_f3 * c_f3));
                    hypsmoothE124 = hypsmooth;
                end
                vfbsd = devsign * (PHIG_i - (EASUB + 0.5 * Eg - devsign * (0.5 * Eg - hypsmoothE124)));
            end
        end
        else begin
            vfbsd = VFBSD;
        end
        if (!$param_given(VFBSDCV)) begin
            vfbsdcv = vfbsd;
        end
        else begin
            vfbsdcv = VFBSDCV;
        end
        if (SHMOD != 0 && RTH0 > 0.0) begin
            _argR125_1_ = nbody / ni;
            begin : llnE125
                real lln;
                real x_f2;

                x_f2 = _argR125_1_;
                lln = ln(max(x_f2,9.9999999999999996e-39));
                llnE125 = lln;
            end
            T0 = Vtm * llnE125;
            phib = sqrt(T0 * T0 + 1e-06);
        end
        else begin
            _argR126_1_ = nbody / ni;
            begin : llnE126
                real lln;
                real x_f2;

                x_f2 = _argR126_1_;
                lln = ln(max(x_f2,9.9999999999999996e-39));
                llnE126 = lln;
            end
            phib = Vtm * llnE126;
        end
        if (SHMOD != 0 && RTH0 > 0.0) begin
            _argR127_1_ = nbody * NSD / (ni * ni);
            begin : llnE127
                real lln;
                real x_f2;

                x_f2 = _argR127_1_;
                lln = ln(max(x_f2,9.9999999999999996e-39));
                llnE127 = lln;
            end
            T0 = Vtm * llnE127;
            vbi = sqrt(T0 * T0 + 1e-06);
        end
        else begin
            _argR128_1_ = nbody * NSD / (ni * ni);
            begin : llnE128
                real lln;
                real x_f2;

                x_f2 = _argR128_1_;
                lln = ln(max(x_f2,9.9999999999999996e-39));
                llnE128 = lln;
            end
            vbi = Vtm * llnE128;
        end
        deltaPhi = devsign * (PHIG_i - (EASUB + ((TYPE == 1)?0:Eg)));
        eta_mu = 0.5 * ETAMOB_t;
        eta_mu_cv = 0.5;
        if (TYPE != 1) begin
            eta_mu = 1.0 / 3.0 * ETAMOB_t;
            eta_mu_cv = 1.0 / 3.0;
        end
        if (BULKMOD != 0) begin
            Isbs = ASEJ * JSS_t + PSEJ * JSWS_t + TFIN * NFINtotal * JSWGS_t;
            if (Isbs > 0.0) begin
                Nvtms = Vtm * NJS;
                _argR129_1_ = -BVS / Nvtms;
                begin : lexpE129
                    real lexp;
                    real x_f1;

                    x_f1 = _argR129_1_;
                    if (x_f1 > 80.0) begin
                        lexp = 5.540622384000e+34 * (1.0 + x_f1 - 80.0);
                    end
                    else if (x_f1 < -80.0) begin
                        lexp = 1.804851387e-35;
                    end
                    else begin
                        lexp = exp(x_f1);
                    end
                    lexpE129 = lexp;
                end
                XExpBVS = lexpE129 * XJBVS;
                T2 = max(IJTHSFWD / Isbs,10.0);
                Tb = 1.0 + T2 - XExpBVS;
                _argR130_1_ = 0.5 * (Tb + sqrt(Tb * Tb + 4.0 * XExpBVS));
                begin : llnE130
                    real lln;
                    real x_f2;

                    x_f2 = _argR130_1_;
                    lln = ln(max(x_f2,9.9999999999999996e-39));
                    llnE130 = lln;
                end
                VjsmFwd = Nvtms * llnE130;
                _argR131_1_ = VjsmFwd / Nvtms;
                begin : lexpE131
                    real lexp;
                    real x_f1;

                    x_f1 = _argR131_1_;
                    if (x_f1 > 80.0) begin
                        lexp = 5.540622384000e+34 * (1.0 + x_f1 - 80.0);
                    end
                    else if (x_f1 < -80.0) begin
                        lexp = 1.804851387e-35;
                    end
                    else begin
                        lexp = exp(x_f1);
                    end
                    lexpE131 = lexp;
                end
                T0 = lexpE131;
                IVjsmFwd = Isbs * (T0 - XExpBVS / T0 + XExpBVS - 1.0);
                SslpFwd = Isbs * (T0 + XExpBVS / T0) / Nvtms;
                _argR132_1_ = IJTHSREV / Isbs - 10.0;
                _argR132_2_ = 0.001;
                begin : hypsmoothE132
                    real hypsmooth;
                    real x_f3, c_f3;

                    x_f3 = _argR132_1_;
                    c_f3 = _argR132_2_;
                    hypsmooth = 0.5 * (x_f3 + sqrt(x_f3 * x_f3 + 4.0 * c_f3 * c_f3));
                    hypsmoothE132 = hypsmooth;
                end
                T2 = hypsmoothE132 + 10.0;
                _argR133_1_ = (T2 - 1.0) / XJBVS;
                begin : llnE133
                    real lln;
                    real x_f2;

                    x_f2 = _argR133_1_;
                    lln = ln(max(x_f2,9.9999999999999996e-39));
                    llnE133 = lln;
                end
                VjsmRev = -BVS - Nvtms * llnE133;
                _argR134_1_ = -(BVS + VjsmRev) / Nvtms;
                begin : lexpE134
                    real lexp;
                    real x_f1;

                    x_f1 = _argR134_1_;
                    if (x_f1 > 80.0) begin
                        lexp = 5.540622384000e+34 * (1.0 + x_f1 - 80.0);
                    end
                    else if (x_f1 < -80.0) begin
                        lexp = 1.804851387e-35;
                    end
                    else begin
                        lexp = exp(x_f1);
                    end
                    lexpE134 = lexp;
                end
                T1 = XJBVS * lexpE134;
                IVjsmRev = Isbs * (1.0 + T1);
                SslpRev = -Isbs * T1 / Nvtms;
            end
            Isbd = ADEJ * JSD_t + PDEJ * JSWD_t + TFIN * NFINtotal * JSWGD_t;
            if (Isbd > 0.0) begin
                Nvtmd = Vtm * NJD;
                _argR135_1_ = -BVD / Nvtmd;
                begin : lexpE135
                    real lexp;
                    real x_f1;

                    x_f1 = _argR135_1_;
                    if (x_f1 > 80.0) begin
                        lexp = 5.540622384000e+34 * (1.0 + x_f1 - 80.0);
                    end
                    else if (x_f1 < -80.0) begin
                        lexp = 1.804851387e-35;
                    end
                    else begin
                        lexp = exp(x_f1);
                    end
                    lexpE135 = lexp;
                end
                XExpBVD = lexpE135 * XJBVD;
                T2 = max(IJTHDFWD / Isbd,10.0);
                Tb = 1.0 + T2 - XExpBVD;
                _argR136_1_ = 0.5 * (Tb + sqrt(Tb * Tb + 4.0 * XExpBVD));
                begin : llnE136
                    real lln;
                    real x_f2;

                    x_f2 = _argR136_1_;
                    lln = ln(max(x_f2,9.9999999999999996e-39));
                    llnE136 = lln;
                end
                VjdmFwd = Nvtmd * llnE136;
                _argR137_1_ = VjdmFwd / Nvtmd;
                begin : lexpE137
                    real lexp;
                    real x_f1;

                    x_f1 = _argR137_1_;
                    if (x_f1 > 80.0) begin
                        lexp = 5.540622384000e+34 * (1.0 + x_f1 - 80.0);
                    end
                    else if (x_f1 < -80.0) begin
                        lexp = 1.804851387e-35;
                    end
                    else begin
                        lexp = exp(x_f1);
                    end
                    lexpE137 = lexp;
                end
                T0 = lexpE137;
                IVjdmFwd = Isbd * (T0 - XExpBVD / T0 + XExpBVD - 1.0);
                DslpFwd = Isbd * (T0 + XExpBVD / T0) / Nvtmd;
                _argR138_1_ = IJTHDREV / Isbd - 10.0;
                _argR138_2_ = 0.001;
                begin : hypsmoothE138
                    real hypsmooth;
                    real x_f3, c_f3;

                    x_f3 = _argR138_1_;
                    c_f3 = _argR138_2_;
                    hypsmooth = 0.5 * (x_f3 + sqrt(x_f3 * x_f3 + 4.0 * c_f3 * c_f3));
                    hypsmoothE138 = hypsmooth;
                end
                T2 = hypsmoothE138 + 10.0;
                _argR139_1_ = (T2 - 1.0) / XJBVD;
                begin : llnE139
                    real lln;
                    real x_f2;

                    x_f2 = _argR139_1_;
                    lln = ln(max(x_f2,9.9999999999999996e-39));
                    llnE139 = lln;
                end
                VjdmRev = -BVD - Nvtmd * llnE139;
                _argR140_1_ = -(BVD + VjdmRev) / Nvtmd;
                begin : lexpE140
                    real lexp;
                    real x_f1;

                    x_f1 = _argR140_1_;
                    if (x_f1 > 80.0) begin
                        lexp = 5.540622384000e+34 * (1.0 + x_f1 - 80.0);
                    end
                    else if (x_f1 < -80.0) begin
                        lexp = 1.804851387e-35;
                    end
                    else begin
                        lexp = exp(x_f1);
                    end
                    lexpE140 = lexp;
                end
                T1 = XJBVD * lexpE140;
                IVjdmRev = Isbd * (1.0 + T1);
                DslpRev = -Isbd * T1 / Nvtmd;
            end
            Czbs = CJS_t * ASEJ;
            Czbssw = CJSWS_t * PSEJ;
            Czbsswg = CJSWGS_t * Weff0 * NFINtotal;
            Czbd = CJD_t * ADEJ;
            Czbdsw = CJSWD_t * PDEJ;
            Czbdswg = CJSWGD_t * Weff0 * NFINtotal;
        end
        T0 = Eg / Vtm * (TRatio - 1.0);
        T1 = T0 / NTGEN_i;
        _argR141_1_ = T1;
        begin : lexpE141
            real lexp;
            real x_f1;

            x_f1 = _argR141_1_;
            if (x_f1 > 80.0) begin
                lexp = 5.540622384000e+34 * (1.0 + x_f1 - 80.0);
            end
            else if (x_f1 < -80.0) begin
                lexp = 1.804851387e-35;
            end
            else begin
                lexp = exp(x_f1);
            end
            lexpE141 = lexp;
        end
        igentemp = lexpE141;
    end
    vgs_noswap = devsign * V(ge,si);
    vds_noswap = devsign * V(di,si);
    vgd_noswap = devsign * V(ge,di);
    ves_jct = devsign * V(e,si);
    ved_jct = devsign * V(e,di);
    vge = devsign * V(ge,e);
    sigvds = 1.0;
    if (vds_noswap < 0.0) begin
        sigvds = -1.0;
        vgs = vgs_noswap - vds_noswap;
        vds = -1.0 * vds_noswap;
        ves = ved_jct;
    end
    else begin
        vgs = vgs_noswap;
        vds = vds_noswap;
        ves = ves_jct;
    end
    vgsfb = vgs - deltaPhi;
    etaiv = 0.0;
    Qes = 0.0;
    Qesj = 0.0;
    Qeg = 0.0;
    Qed = 0.0;
    Qedj = 0.0;
    vdsx = sqrt(vds * vds + 0.01) - 0.1;
    if (BULKMOD != 0) begin
        vesx = ves - 0.5 * (vds - vdsx);
        vesmax = 0.95 * PHIBE_i;
        T2 = vesmax - vesx - 0.001;
        veseff = vesmax - 0.5 * (T2 + sqrt(T2 * T2 + 0.004 * vesmax));
    end
    T0 = tanh(0.6 * vds_noswap / Vtm);
    wf = 0.5 + 0.5 * T0;
    wr = 1.0 - wf;
    if (ASYMMOD != 0) begin
        CDSCD_a = CDSCDR_i * wr + CDSCD_i * wf;
        ETA0_a = ETA0R_t * wr + ETA0_t * wf;
        PDIBL1_a = PDIBL1R_i * wr + PDIBL1_i * wf;
        PDIBL2_a = PDIBL2R_i * wr + PDIBL2_i * wf;
        MEXP_a = MEXPR_t * wr + MEXP_t * wf;
        PTWG_a = PTWGR_t * wr + PTWG_t * wf;
        VSAT1_a = VSAT1R_t * wr + VSAT1_t * wf;
        RSDR_a = RSDRR_t * wr + RSDR_t * wf;
        RDDR_a = RDDRR_t * wr + RDDR_t * wf;
        PCLM_a = PCLMR_i * wr + PCLM_i * wf;
        VSAT_a = VSATR_t * wr + VSAT_t * wf;
        KSATIV_a = KSATIVR_i * wr + KSATIV_i * wf;
        DVTSHIFT_a = DVTSHIFTR_i * wr + DVTSHIFT_i * wf;
        CIT_a = CITR_i * wr + CIT_i * wf;
        u0_a = u0r * wr + u0 * wf;
        UA_a = UAR_t * wr + UA_t * wf;
        UD_a = UDR_t * wr + UD_t * wf;
        UC_a = UCR_t * wr + UC_t * wf;
        EU_a = EUR_i * wr + EU_i * wf;
    end
    else begin
        CDSCD_a = CDSCD_i;
        ETA0_a = ETA0_t;
        PDIBL1_a = PDIBL1_i;
        PDIBL2_a = PDIBL2_i;
        MEXP_a = MEXP_t;
        PTWG_a = PTWG_t;
        VSAT1_a = VSAT1_t;
        RSDR_a = RSDR_t;
        RDDR_a = RDDR_t;
        PCLM_a = PCLM_i;
        VSAT_a = VSAT_t;
        KSATIV_a = KSATIV_i;
        DVTSHIFT_a = DVTSHIFT_i;
        CIT_a = CIT_i;
        u0_a = u0;
        UA_a = UA_t;
        UD_a = UD_t;
        UC_a = UC_t;
        EU_a = EU_i;
    end
    inv_MEXP = 1.0 / MEXP_a;
    phist = 0.4 + phib + PHIN_i;
    T1 = 2.0 * (Cins / Weff_UFCM) / (rc + 2.0);
    cdsc = Theta_SW * (CDSC_i + CDSCD_a * vdsx);
    if (!$param_given(NVTM)) nVtm = Vtm * ThetaSS * (1.0 + (CIT_a + cdsc) / T1);
    else nVtm = NVTM;
    qdep = Qdep_ov_Cins / nVtm;
    vth_fixed_factor_SI = ln(Cins * nVtm / (1.6021899999999999e-19 * Nc * 2.0 * Ach));
    vth_fixed_factor_Sub = ln((qdep * rc) * (qdep * rc) / ((exp(qdep * rc) - qdep * rc - 1.0))) + vth_fixed_factor_SI;
    q0 = 10.0 * nVtm / rc + 2.0 * qbs;
    fieldnormalizationfactor = Vtm * Cins / (Weff_UFCM * epssub);
    auxQMfact = pow(((3.0 / 4.0) * 3.0 * 1.05457e-34 * 2.0 * 3.141592653589793 * 1.6021899999999999e-19 / (4.0 * sqrt(2.0 * mx))),2.0 / 3.0);
    QMFACTORCVfinal = QMFACTORCV * auxQMfact * pow(fieldnormalizationfactor,2.0 / 3.0) * (1 / (1.6021899999999999e-19 * Vtm));
    dvth_vtroll = -DVT0_i * Theta_SCE * (vbi - phist);
    dvth_dibl = -ETA0_a * Theta_DIBL * vdsx + (DVTP0_i * Theta_DITS * pow(vdsx,DVTP1_i));
    dvth_rsce = K1RSCE_i * Theta_RSCE * sqrt(phist);
    dvth_all = dvth_vtroll + dvth_dibl + dvth_rsce + dvth_temp + DVTSHIFT_a;
    vgsfb = vgsfb - dvth_all;
    beta0 = u0_a * cox * Weff0 / Leff;
    _argR142_1_ = 2.0 * cox * Imin / (beta0 * nVtm * 1.6021899999999999e-19 * Nc * TFIN);
    begin : llnE142
        real lln;
        real x_f2;

        x_f2 = _argR142_1_;
        lln = ln(max(x_f2,9.9999999999999996e-39));
        llnE142 = lln;
    end
    T0 = -(dvch_qm + nVtm * llnE142);
    T1 = vgsfb + T0 + DELVTRAND;
    _argR143_1_ = T1;
    _argR143_2_ = 0.0001;
    begin : hypsmoothE143
        real hypsmooth;
        real x_f3, c_f3;

        x_f3 = _argR143_1_;
        c_f3 = _argR143_2_;
        hypsmooth = 0.5 * (x_f3 + sqrt(x_f3 * x_f3 + 4.0 * c_f3 * c_f3));
        hypsmoothE143 = hypsmooth;
    end
    vgsfbeff = hypsmoothE143 - T0;
    vch = 0.0 + dvch_qm;
    if (BULKMOD != 0) begin
        _argR144_1_ = 2.0 * phib + vch - ves;
        _argR144_2_ = 0.1;
        begin : hypsmoothE144
            real hypsmooth;
            real x_f3, c_f3;

            x_f3 = _argR144_1_;
            c_f3 = _argR144_2_;
            hypsmooth = 0.5 * (x_f3 + sqrt(x_f3 * x_f3 + 4.0 * c_f3 * c_f3));
            hypsmoothE144 = hypsmooth;
        end
        T1 = hypsmoothE144;
        T3 = (-K1_t / (2.0 * nVtm)) * (sqrt(T1) - sqrt(2.0 * phib));
        T0 = -qdep - T3 + vth_fixed_factor_Sub + QMFACTORCVfinal * pow(-qdep,2.0 / 3.0);
        T1 = -qdep - T3 + vth_fixed_factor_SI;
    end
    else begin
        T0 = -qdep + vth_fixed_factor_Sub + QMFACTORCVfinal * pow(-qdep,2.0 / 3.0);
        T1 = -qdep + vth_fixed_factor_SI;
    end
    T2 = (vgsfbeff - vch) / nVtm;
    F0 = -T2 + T1;
    T3 = 0.5 * (T2 - T0);
    qm = exp(T3);
    if (qm > 1e-07) begin
        T7 = ln(1.0 + qm);
        qm = 2.0 * (1.0 - sqrt(1.0 + T7 * T7));
        T8 = (qm * ALPHA_UFCM + qdep) * rc;
        T4 = T8 / (exp(T8) - T8 - 1.0);
        T5 = T8 * T4;
        e0 = F0 - qm + ln(-qm) + ln(T5) + QMFACTORCVfinal * pow(-(qm + qdep),2.0 / 3.0);
        e1 = -1.0 + 1.0 / qm + (2.0 / T8 - T4 - 1.0) * rc - (2.0 / 3.0) * QMFACTORCVfinal * pow(-(qm + qdep),-1.0 / 3.0);
        e2 = -1.0 / (qm * qm) - (2.0 / 9.0) * QMFACTORCVfinal * pow(-(qm + qdep),-4.0 / 3.0);
        qm = qm - (e0 / e1) * (1.0 + (e0 * e2) / (2.0 * e1 * e1));
        T8 = (qm * ALPHA_UFCM + qdep) * rc;
        T4 = T8 / (exp(T8) - T8 - 1.0);
        T5 = T8 * T4;
        e0 = F0 - qm + ln(-qm) + ln(T5) + QMFACTORCVfinal * pow(-(qm + qdep),2.0 / 3.0);
        e1 = -1.0 + 1.0 / qm + (2.0 / T8 - T4 - 1.0) * rc - (2.0 / 3.0) * QMFACTORCVfinal * pow(-(qm + qdep),-1.0 / 3.0);
        e2 = -1.0 / (qm * qm) - (2.0 / 9.0) * QMFACTORCVfinal * pow(-(qm + qdep),-4.0 / 3.0);
        qm = qm - (e0 / e1) * (1.0 + (e0 * e2) / (2.0 * e1 * e1));
    end
    else begin
        qm = -qm * qm;
    end
    qis = -qm * nVtm;
    Eeffs = EeffFactor * (qbs + eta_mu * qis);
    qb0 = 0.01 / cox;
    T2 = pow(0.5 * (1.0 + abs((qis) / qb0)),UCS_t);
    if (BULKMOD != 0) begin
        T3 = (UA_a + UC_a * veseff) * pow(abs(Eeffs),EU_a) + UD_a / T2;
    end
    else begin
        T3 = UA_a * pow(abs(Eeffs),EU_a) + UD_a / T2;
    end
    Dmobs = 1.0 + T3;
    Dmobs = Dmobs / U0MULT;
    if (RDSMOD == 1) begin
        Rdss = 0.0;
    end
    else if (RDSMOD == 0) begin
        T4 = 1.0 + PRWGS_i * qis;
        T1 = 1.0 / T4;
        T0 = 0.5 * (T1 + sqrt(T1 * T1 + 0.01));
        Rdss = (RDSWMIN_i + RDSW_i * T0) * WeffWRFactor * NFINtotal * rdstemp;
    end
    else begin
        T4 = 1.0 + PRWGS_i * qis;
        T1 = 1.0 / T4;
        T0 = 0.5 * (T1 + sqrt(T1 * T1 + 0.01));
        Rdss = (RSourceGeo + RDrainGeo + RDSWMIN_i + RDSW_i * T0) * WeffWRFactor * NFINtotal * rdstemp;
    end
    Esat = 2.0 * VSAT_a / u0_a * Dmobs;
    EsatL = Esat * Leff;
    T6 = KSATIV_a * (qis + 2 * Vtm);
    if (Rdss == 0.0) begin
        Vdsat = EsatL * T6 / (EsatL + T6);
    end
    else begin
        WVCox = Weff0 * VSAT_a * cox;
        T0 = WVCox * Rdss;
        Ta = 2.0 * T0;
        Tb = T6 + EsatL + 3.0 * T6 * T0;
        Tc = T6 * (EsatL + 2.0 * T6 * T0);
        Vdsat = (Tb - sqrt(Tb * Tb - 2.0 * Ta * Tc)) / Ta;
    end
    _argR145_1_ = Vdsat - 0.001;
    _argR145_2_ = 1e-05;
    begin : hypsmoothE145
        real hypsmooth;
        real x_f3, c_f3;

        x_f3 = _argR145_1_;
        c_f3 = _argR145_2_;
        hypsmooth = 0.5 * (x_f3 + sqrt(x_f3 * x_f3 + 4.0 * c_f3 * c_f3));
        hypsmoothE145 = hypsmooth;
    end
    Vdsat = hypsmoothE145 + 0.001;
    T7 = pow(vds / Vdsat,MEXP_a);
    T8 = pow(1.0 + T7,inv_MEXP);
    Vdseff = vds / T8;
    if (Vdseff > vds) begin
        Vdseff = vds;
    end
    vch = Vdseff + dvch_qm;
    if (BULKMOD != 0) begin
        _argR146_1_ = 2.0 * phib + vch - ves;
        _argR146_2_ = 0.1;
        begin : hypsmoothE146
            real hypsmooth;
            real x_f3, c_f3;

            x_f3 = _argR146_1_;
            c_f3 = _argR146_2_;
            hypsmooth = 0.5 * (x_f3 + sqrt(x_f3 * x_f3 + 4.0 * c_f3 * c_f3));
            hypsmoothE146 = hypsmooth;
        end
        T1 = hypsmoothE146;
        T3 = (-K1_t / (2.0 * nVtm)) * (sqrt(T1) - sqrt(2.0 * phib));
        T0 = -qdep - T3 + vth_fixed_factor_Sub + QMFACTORCVfinal * pow(-qdep,2.0 / 3.0);
        T1 = -qdep - T3 + vth_fixed_factor_SI;
    end
    else begin
        T0 = -qdep + vth_fixed_factor_Sub + QMFACTORCVfinal * pow(-qdep,2.0 / 3.0);
        T1 = -qdep + vth_fixed_factor_SI;
    end
    T2 = (vgsfbeff - vch) / nVtm;
    F0 = -T2 + T1;
    T3 = (T2 - T0) * 0.5;
    qm = exp(T3);
    if (qm > 1e-07) begin
        T7 = ln(1.0 + qm);
        qm = 2.0 * (1.0 - sqrt(1.0 + T7 * T7));
        T8 = (qm * ALPHA_UFCM + qdep) * rc;
        T4 = T8 / (exp(T8) - T8 - 1.0);
        T5 = T8 * T4;
        e0 = F0 - qm + ln(-qm) + ln(T5) + QMFACTORCVfinal * pow(-(qm + qdep),2.0 / 3.0);
        e1 = -1.0 + (1.0 / qm) + (2.0 / T8 - T4 - 1.0) * rc - (2.0 / 3.0) * QMFACTORCVfinal * pow(-(qm + qdep),-1.0 / 3.0);
        e2 = -1.0 / (qm * qm) - (2.0 / 9.0) * QMFACTORCVfinal * pow(-(qm + qdep),-4.0 / 3.0);
        qm = qm - (e0 / e1) * (1.0 + (e0 * e2) / (2.0 * e1 * e1));
        T8 = (qm * ALPHA_UFCM + qdep) * rc;
        T4 = T8 / (exp(T8) - T8 - 1.0);
        T5 = T8 * T4;
        e0 = F0 - qm + ln(-qm) + ln(T5) + QMFACTORCVfinal * pow(-(qm + qdep),2.0 / 3.0);
        e1 = -1.0 + (1.0 / qm) + (2.0 / T8 - T4 - 1.0) * rc - (2.0 / 3.0) * QMFACTORCVfinal * pow(-(qm + qdep),-1.0 / 3.0);
        e2 = -1.0 / (qm * qm) - (2.0 / 9.0) * QMFACTORCVfinal * pow(-(qm + qdep),-4.0 / 3.0);
        qm = qm - (e0 / e1) * (1.0 + (e0 * e2) / (2.0 * e1 * e1));
    end
    else begin
        qm = -qm * qm;
    end
    qid = -qm * nVtm;
    if (BULKMOD != 0) begin
        T9 = (K1_t / (2.0 * nVtm)) * sqrt(Vtm);
        T0 = T9 / 2.0;
        T2 = (vge - (deltaPhi - Eg - Vtm * ln(NBODY / Nc) + DELVFBACC)) / Vtm;
        if ((T2 * Vtm) > phib + T9 * sqrt(phib * Vtm)) begin
            T1 = sqrt(T2 - 1.0 + T0 * T0) - T0;
            T10 = 1.0 + T1 * T1;
        end
        else begin
            T3 = T2 * 0.5 - 3.0 * (1.0 + T9 / sqrt(2.0));
            T10 = T3 + sqrt(T3 * T3 + 6.0 * T2);
            if (T2 < 0.0) begin
                T4 = (T2 - T10) / T9;
                T10 = -ln(1.0 - T10 + T4 * T4);
            end
            else begin
                T11 = exp(-T10);
                T4 = sqrt(T2 - 1.0 + T11 + T0 * T0) - T0;
                T10 = 1.0 - T11 + T4 * T4;
            end
        end
        T6 = exp(-T10) - 1.0;
        T7 = sqrt(T6 + T10);
        if (T10 > 1e-15) begin
            e0 = -(T2 - T10) + T9 * T7;
            e1 = 1.0 - T9 * 0.5 * T6 / T7;
            T8 = T10 - (e0 / e1);
            T11 = exp(-T8) - 1.0;
            T12 = sqrt(T11 + T8);
            qba = -T9 * T12 * Vtm;
        end
        else begin
            if (T10 < -1e-15) begin
                e0 = -(T2 - T10) - T9 * T7;
                e1 = 1.0 + T9 * 0.5 * T6 / T7;
                T8 = T10 - e0 / e1;
                T12 = T9 * sqrt(exp(-T8) + T8 - 1.0);
            end
            else begin
                T12 = 0.0;
                T8 = 0.0;
            end
            qba = T12 * Vtm;
        end
        qi_acc_for_QM = T9 * exp(-T8 / 2.0) * Vtm;
        psipclamp = 0.5 * (T8 + 1.0 + sqrt((T8 - 1.0) * (T8 - 1.0) + 0.25 * 2.0 * 2.0));
        sqrtpsip = sqrt(psipclamp);
        nq = 1.0 + T9 / sqrtpsip;
    end
    qia = 0.5 * (qis + qid);
    dqi = qis - qid;
    T0 = pow(Vdseff,2.0) / 0.000625;
    if (CHARGEWF != 0.0) begin
        _argR147_1_ = -T0;
        begin : lexpE147
            real lexp;
            real x_f1;

            x_f1 = _argR147_1_;
            if (x_f1 > 80.0) begin
                lexp = 5.540622384000e+34 * (1.0 + x_f1 - 80.0);
            end
            else if (x_f1 < -80.0) begin
                lexp = 1.804851387e-35;
            end
            else begin
                lexp = exp(x_f1);
            end
            lexpE147 = lexp;
        end
        qia2 = 0.5 * (qis + qid) + CHARGEWF * (1.0 - lexpE147) * 0.5 * dqi;
    end
    else qia2 = 0.5 * (qis + qid);
    if (qis < 0.0) $strobe("Warning: negative source-side inversion carrier density.  Vgs=%f  Vds=%f  Vbs=%f qis=%e",V(g,s),V(d,s),V(e,s),qis);
    if (qid < 0.0) $strobe("Warning: negative drain-side inversion carrier density.  Vgs=%f  Vds=%f  Vbs=%f qid=%e",V(g,s),V(d,s),V(e,s),qid);
    if (QMTCENCV_i > 0.0) begin
        T4 = qia / QM0;
        T5 = 1.0 + pow(T4,PQM);
        Tcen = Tcen0 / T5;
        coxeff = 1.0 / (1.0 / (cox * EOT / TOXP) + Tcen * QMTCENCV_i / epssub);
    end
    else begin
        coxeff = cox;
    end
    if (BULKMOD != 0 && QMTCENCVA_i != 0.0) begin
        T6 = 1.0 + pow(qi_acc_for_QM / QM0ACC,PQMACC);
        Tcen = Tcen0 / T6;
        cox_acc = 1.0 / (1.0 / cox_acc + Tcen * QMTCENCVA_i / epssub);
    end
    beta = u0_a * cox * Weff0 / Leff;
    Eeffm = EeffFactor * (qba + eta_mu * qia2);
    T2 = pow(0.5 * (1.0 + abs((qia2) / qb0)),UCS_t);
    if (BULKMOD != 0) begin
        T3 = (UA_a + UC_a * veseff) * pow(abs(Eeffm),EU_a) + UD_a / T2;
    end
    else begin
        T3 = UA_a * pow(abs(Eeffm),EU_a) + UD_a / T2;
    end
    Dmob = 1.0 + T3;
    Dmob = Dmob / U0MULT;
    ueff = u0_a / Dmob;
    Eeffm_cv = EeffFactor * (qba + eta_mu_cv * qia2);
    T3 = UA_a * pow(abs(Eeffm_cv),EU_a) + UD_a / T2;
    Dmob_cv = 1.0 + T3;
    Dmob_cv = Dmob_cv / U0MULT;
    tmp = DROUT_i * Leff / scl + 1e-06;
    if (tmp < 40.0) begin
        DIBLfactor = 0.5 * PDIBL1_a / (cosh(tmp) - 1.0) + PDIBL2_a;
    end
    else begin
        DIBLfactor = PDIBL1_a * exp(-tmp) + PDIBL2_a;
    end
    if (PVAG_i > 0.0) begin
        PVAGfactor = 1.0 + PVAG_i * qia / EsatL;
    end
    else begin
        PVAGfactor = 1.0 / (1.0 - PVAG_i * qia / EsatL);
    end
    if (Vdseff > vds) begin
        Vdseff = vds;
    end
    diffVds = vds - Vdseff;
    Vgst2Vtm = qia + 2.0 * Vtm;
    if (DIBLfactor > 0) begin
        T1 = Vgst2Vtm;
        T3 = T1 / (Vdsat + T1);
        VaDIBL = T1 / DIBLfactor * T3 * PVAGfactor;
        Moc = 1.0 + diffVds / VaDIBL;
    end
    else begin
        Moc = 1.0;
    end
    if (PCLM_a > 0.0) begin
        if (PCLMG_i < 0.0) begin
            T1 = 1.0 / (1.0 / PCLM_a - PCLMG_i * qia);
        end
        else begin
            T1 = PCLM_a + PCLMG_i * qia;
        end
        _argR148_1_ = 1.0 + (vds - Vdseff) / T1 / (Vdsat + EsatL);
        begin : llnE148
            real lln;
            real x_f2;

            x_f2 = _argR148_1_;
            lln = ln(max(x_f2,9.9999999999999996e-39));
            llnE148 = lln;
        end
        Mclm = 1.0 + T1 * llnE148;
    end
    else begin
        Mclm = 1.0;
    end
    Moc = Moc * Mclm;
    Esat1 = 2.0 * VSAT1_a / ueff;
    Esat1L = Esat1 * Leff;
    _argR149_1_ = dqi / Esat1L;
    begin : llnE149
        real lln;
        real x_f2;

        x_f2 = _argR149_1_;
        lln = ln(max(x_f2,9.9999999999999996e-39));
        llnE149 = lln;
    end
    _argR150_1_ = PSAT_i * llnE149;
    begin : lexpE150
        real lexp;
        real x_f1;

        x_f1 = _argR150_1_;
        if (x_f1 > 80.0) begin
            lexp = 5.540622384000e+34 * (1.0 + x_f1 - 80.0);
        end
        else if (x_f1 < -80.0) begin
            lexp = 1.804851387e-35;
        end
        else begin
            lexp = exp(x_f1);
        end
        lexpE150 = lexp;
    end
    T0 = lexpE150;
    _argR151_1_ = DELTAVSAT_i;
    begin : llnE151
        real lln;
        real x_f2;

        x_f2 = _argR151_1_;
        lln = ln(max(x_f2,9.9999999999999996e-39));
        llnE151 = lln;
    end
    _argR152_1_ = 1.0 / PSAT_i * llnE151;
    begin : lexpE152
        real lexp;
        real x_f1;

        x_f1 = _argR152_1_;
        if (x_f1 > 80.0) begin
            lexp = 5.540622384000e+34 * (1.0 + x_f1 - 80.0);
        end
        else if (x_f1 < -80.0) begin
            lexp = 1.804851387e-35;
        end
        else begin
            lexp = exp(x_f1);
        end
        lexpE152 = lexp;
    end
    Ta = (1.0 + lexpE152);
    _argR153_1_ = DELTAVSAT_i + T0;
    begin : llnE153
        real lln;
        real x_f2;

        x_f2 = _argR153_1_;
        lln = ln(max(x_f2,9.9999999999999996e-39));
        llnE153 = lln;
    end
    _argR154_1_ = 1.0 / PSAT_i * llnE153;
    begin : lexpE154
        real lexp;
        real x_f1;

        x_f1 = _argR154_1_;
        if (x_f1 > 80.0) begin
            lexp = 5.540622384000e+34 * (1.0 + x_f1 - 80.0);
        end
        else if (x_f1 < -80.0) begin
            lexp = 1.804851387e-35;
        end
        else begin
            lexp = exp(x_f1);
        end
        lexpE154 = lexp;
    end
    Dvsat = (1.0 + lexpE154) / Ta;
    Dvsat = Dvsat + 0.5 * PTWG_a * qia * dqi * dqi;
    T0 = A1_t + A2_t / (qia + 2.0 * nVtm);
    T1 = T0 * dqi * dqi;
    T2 = T1 + 1.0 - 0.001;
    T3 = -1.0 + 0.5 * (T2 + sqrt(T2 * T2 + 0.004));
    Nsat = 0.5 * (1.0 + sqrt(1.0 + T3));
    Dvsat = Dvsat * Nsat;
    if (K0_t != 0) begin
        T1 = K0_t / (max(0,K0SI_t + K0SISAT_t * dqi * dqi) * qia + 2.0 * nVtm);
        _argR155_1_ = -T1;
        begin : lexpE155
            real lexp;
            real x_f1;

            x_f1 = _argR155_1_;
            if (x_f1 > 80.0) begin
                lexp = 5.540622384000e+34 * (1.0 + x_f1 - 80.0);
            end
            else if (x_f1 < -80.0) begin
                lexp = 1.804851387e-35;
            end
            else begin
                lexp = exp(x_f1);
            end
            lexpE155 = lexp;
        end
        Mnud = lexpE155;
    end
    else begin
        Mnud = 1.0;
    end
    if (BULKMOD == 2) begin
        _argR156_1_ = (K2_t + K2SAT_t * vdsx);
        _argR156_2_ = 1e-06;
        begin : hypsmoothE156
            real hypsmooth;
            real x_f3, c_f3;

            x_f3 = _argR156_1_;
            c_f3 = _argR156_2_;
            hypsmooth = 0.5 * (x_f3 + sqrt(x_f3 * x_f3 + 4.0 * c_f3 * c_f3));
            hypsmoothE156 = hypsmooth;
        end
        T0 = hypsmoothE156;
        T1 = T0 / (max(0,K2SI_t + K2SISAT_t * dqi * dqi) * qia + 2.0 * nVtm);
        T3 = sqrt(PHIBE_i - veseff) - sqrt(PHIBE_i);
        _argR157_1_ = -T1 * T3;
        begin : lexpE157
            real lexp;
            real x_f1;

            x_f1 = _argR157_1_;
            if (x_f1 > 80.0) begin
                lexp = 5.540622384000e+34 * (1.0 + x_f1 - 80.0);
            end
            else if (x_f1 < -80.0) begin
                lexp = 1.804851387e-35;
            end
            else begin
                lexp = exp(x_f1);
            end
            lexpE157 = lexp;
        end
        Mob = lexpE157;
    end
    else Mob = 1.0;
    EsatCV = 2.0 * VSATCV_t * Dmob_cv / u0_a;
    EsatCVL = EsatCV * LeffCV;
    _argR158_1_ = dqi / EsatCVL;
    begin : llnE158
        real lln;
        real x_f2;

        x_f2 = _argR158_1_;
        lln = ln(max(x_f2,9.9999999999999996e-39));
        llnE158 = lln;
    end
    _argR159_1_ = PSATCV_i * llnE158;
    begin : lexpE159
        real lexp;
        real x_f1;

        x_f1 = _argR159_1_;
        if (x_f1 > 80.0) begin
            lexp = 5.540622384000e+34 * (1.0 + x_f1 - 80.0);
        end
        else if (x_f1 < -80.0) begin
            lexp = 1.804851387e-35;
        end
        else begin
            lexp = exp(x_f1);
        end
        lexpE159 = lexp;
    end
    T0 = lexpE159;
    _argR160_1_ = DELTAVSATCV_i;
    begin : llnE160
        real lln;
        real x_f2;

        x_f2 = _argR160_1_;
        lln = ln(max(x_f2,9.9999999999999996e-39));
        llnE160 = lln;
    end
    _argR161_1_ = 1.0 / PSATCV_i * llnE160;
    begin : lexpE161
        real lexp;
        real x_f1;

        x_f1 = _argR161_1_;
        if (x_f1 > 80.0) begin
            lexp = 5.540622384000e+34 * (1.0 + x_f1 - 80.0);
        end
        else if (x_f1 < -80.0) begin
            lexp = 1.804851387e-35;
        end
        else begin
            lexp = exp(x_f1);
        end
        lexpE161 = lexp;
    end
    Ta = (1.0 + lexpE161);
    _argR162_1_ = DELTAVSATCV_i + T0;
    begin : llnE162
        real lln;
        real x_f2;

        x_f2 = _argR162_1_;
        lln = ln(max(x_f2,9.9999999999999996e-39));
        llnE162 = lln;
    end
    _argR163_1_ = 1.0 / PSATCV_i * llnE162;
    begin : lexpE163
        real lexp;
        real x_f1;

        x_f1 = _argR163_1_;
        if (x_f1 > 80.0) begin
            lexp = 5.540622384000e+34 * (1.0 + x_f1 - 80.0);
        end
        else if (x_f1 < -80.0) begin
            lexp = 1.804851387e-35;
        end
        else begin
            lexp = exp(x_f1);
        end
        lexpE163 = lexp;
    end
    DvsatCV = (1.0 + lexpE163) / Ta;
    if (PCLMCV_i != 0) begin
        _argR164_1_ = 1.0 + (vds - Vdseff) / PCLMCV_i / (Vdsat + EsatCVL);
        begin : llnE164
            real lln;
            real x_f2;

            x_f2 = _argR164_1_;
            lln = ln(max(x_f2,9.9999999999999996e-39));
            llnE164 = lln;
        end
        MclmCV = 1.0 + PCLMCV_i * llnE164;
    end
    else begin
        MclmCV = 1.0;
    end
    qb = -1.6021899999999999e-19 * nbody * Ach * LeffCV;
    T1 = qia;
    etaiv = q0 / (q0 + qia);
    T2 = (2.0 - etaiv) * nVtm;
    ids0_ov_dqi = T1 + T2;
    ids0 = ids0_ov_dqi * dqi;
    case (RDSMOD)
    1 : begin
        Rdsi = 0.0;
        Dr = 1.0;
        T2 = vgs_noswap - vfbsd;
        T3 = sqrt(T2 * T2 + 0.1);
        vgs_eff = 0.5 * (T2 + T3);
        T4 = 1.0 + PRWGS_i * vgs_eff;
        T1 = 1.0 / T4;
        T0 = 0.5 * (T1 + sqrt(T1 * T1 + 0.01));
        _argR165_1_ = V(si,s) * V(si,s) + 1e-06;
        begin : llnE165
            real lln;
            real x_f2;

            x_f2 = _argR165_1_;
            lln = ln(max(x_f2,9.9999999999999996e-39));
            llnE165 = lln;
        end
        _argR166_1_ = 0.5 * PRSDR * llnE165;
        begin : lexpE166
            real lexp;
            real x_f1;

            x_f1 = _argR166_1_;
            if (x_f1 > 80.0) begin
                lexp = 5.540622384000e+34 * (1.0 + x_f1 - 80.0);
            end
            else if (x_f1 < -80.0) begin
                lexp = 1.804851387e-35;
            end
            else begin
                lexp = exp(x_f1);
            end
            lexpE166 = lexp;
        end
        T5 = RSW_i * (1.0 + RSDR_a * lexpE166);
        Rsource = rdstemp * (RSourceGeo + (RSWMIN_i + T5 * T0) * WeffWRFactor);
        T2 = vgd_noswap - vfbsd;
        T3 = sqrt(T2 * T2 + 0.1);
        vgd_eff = 0.5 * (T2 + T3);
        T4 = 1.0 + PRWGD_i * vgd_eff;
        T1 = 1.0 / T4;
        T0 = 0.5 * (T1 + sqrt(T1 * T1 + 0.01));
        _argR167_1_ = V(di,d) * V(di,d) + 1e-06;
        begin : llnE167
            real lln;
            real x_f2;

            x_f2 = _argR167_1_;
            lln = ln(max(x_f2,9.9999999999999996e-39));
            llnE167 = lln;
        end
        _argR168_1_ = 0.5 * PRDDR * llnE167;
        begin : lexpE168
            real lexp;
            real x_f1;

            x_f1 = _argR168_1_;
            if (x_f1 > 80.0) begin
                lexp = 5.540622384000e+34 * (1.0 + x_f1 - 80.0);
            end
            else if (x_f1 < -80.0) begin
                lexp = 1.804851387e-35;
            end
            else begin
                lexp = exp(x_f1);
            end
            lexpE168 = lexp;
        end
        T5 = RDW_i * (1.0 + RDDR_a * lexpE168);
        Rdrain = rdstemp * (RDrainGeo + (RDWMIN_i + T5 * T0) * WeffWRFactor);
    end
    0 : begin
        Rsource = RSourceGeo;
        Rdrain = RDrainGeo;
        T4 = 1.0 + PRWGS_i * qia;
        T1 = 1.0 / T4;
        T0 = 0.5 * (T1 + sqrt(T1 * T1 + 0.01));
        Rdsi = rdstemp * (RDSWMIN_i + RDSW_i * T0) * WeffWRFactor;
        Dr = 1.0 + (NFINtotal) * beta * ids0_ov_dqi / (Dmob * Dvsat) * Rdsi;
    end
    2 : begin
        T4 = 1.0 + PRWGS_i * qia;
        T1 = 1.0 / T4;
        T0 = 0.5 * (T1 + sqrt(T1 * T1 + 0.01));
        Rdsi = rdstemp * (RSourceGeo + RDrainGeo + RDSWMIN_i + RDSW_i * T0) * WeffWRFactor;
        Dr = 1.0 + (NFINtotal) * beta * ids0_ov_dqi / (Dmob * Dvsat) * Rdsi;
        Rsource = 0.0;
        Rdrain = 0.0;
    end
    endcase

    ids = NFINtotal * beta * ids0 * Moc * Mnud * Mob / (Dmob * Dvsat * Dr);
    ids = ids * IDS0MULT;
    T11 = (2.0 * qia + nVtm) / DvsatCV;
    qg = qia + dqi * dqi / (6.0 * T11);
    qd = -0.5 * (qia - (dqi / (6.0)) * (1.0 - (dqi / T11) * (1 + dqi / (5.0 * T11))));
    inv_MclmCV = 1.0 / MclmCV;
    qg = inv_MclmCV * qg + (MclmCV - 1.0) * qid;
    qd = inv_MclmCV * inv_MclmCV * qd + 0.5 * (MclmCV - inv_MclmCV) * qid;
    qs = -qg - qd;
    T6 = NFINtotal * WeffCV0 * LeffCV * coxeff;
    qg = T6 * qg;
    qd = T6 * qd;
    qs = T6 * qs;
    qinv = qg;
    if (BULKMOD != 0) begin
        T1 = NFINtotal * WeffCV0 * LeffCV_acc * cox_acc;
        T7 = qi_acc_for_QM;
        T10 = T7 * T1;
        qg_acc = -T10;
        qb_acc = T10;
        T1 = NFINtotal * WeffCV0 * LeffCV * cox;
        T2 = qba - qi_acc_for_QM;
        T10 = T1 * T2;
        qg_acc = qg_acc - T10;
        qb_acc = qb_acc + T10;
        T1 = NFINtotal * WeffCV0 * LeffCV * cox;
        T2 = (nq - 1.0) * 0.5 * (qia + (dqi * dqi / (6.0 * T11)));
        T10 = T1 * T2;
        qg_acc = qg_acc - T10;
        qb_acc = qb_acc + T10;
    end
    if (sigvds < 0) begin
        T1 = qd;
        qd = qs;
        qs = T1;
    end
    qgs_ov = 0.0;
    qgd_ov = 0.0;
    if (CGEOMOD != 1) begin
        T1 = NFINtotal * WeffCV0 * devsign;
        T2 = devsign * V(ge,si);
        T0 = T2 - vfbsdcv + 0.02;
        vgs_overlap = 0.5 * (T0 - sqrt(T0 * T0 + 4.0 * 0.02));
        qgs_ov = T1 * (CGSL_i * (T2 - vfbsdcv - vgs_overlap - 0.5 * CKAPPAS_i * (sqrt(1.0 - 4.0 * vgs_overlap / CKAPPAS_i) - 1.0)) + CGSO_i * T2);
        T2 = devsign * V(ge,di);
        T0 = T2 - vfbsdcv + 0.02;
        vgd_overlap = 0.5 * (T0 - sqrt(T0 * T0 + 4.0 * 0.02));
        qgd_ov = T1 * (CGDL_i * (T2 - vfbsdcv - vgd_overlap - 0.5 * CKAPPAD_i * (sqrt(1.0 - 4.0 * vgd_overlap / CKAPPAD_i) - 1.0)) + CGDO_i * T2);
    end
    if (CGEOMOD == 0) begin
        T1 = NFINtotal * WeffCV0;
        qgs_fr = T1 * CFS_i * V(ge,si);
        qgd_fr = T1 * CFD_i * V(ge,di);
        qgs_parasitic = qgs_ov + qgs_fr;
        qgd_parasitic = qgd_ov + qgd_fr;
    end
    else if (CGEOMOD == 1) begin
        if (CGEO1SW == 1) begin
            T0 = NFINtotal * WeffCV0;
            COVS_i = T0 * COVS_i;
            COVD_i = T0 * COVD_i;
            cgsp = T0 * CGSP;
            cgdp = T0 * CGDP;
        end
        else begin
            cgsp = CGSP;
            cgdp = CGDP;
        end
        qgs_ov = COVS_i * V(ge,si);
        qgd_ov = COVD_i * V(ge,di);
        qgs_parasitic = qgs_ov;
        qgd_parasitic = qgd_ov;
        qgs_fr = cgsp * V(ge,s);
        qgd_fr = cgdp * V(ge,d);
    end
    else begin
        qgs_fr = Cfr_geo * V(ge,si);
        qgd_fr = Cfr_geo * V(ge,di);
        qgs_parasitic = qgs_ov + qgs_fr;
        qgd_parasitic = qgd_ov + qgd_fr;
    end
    qds_fr = CDSP * V(d,s);
    Iii = 0.0;
    if (IIMOD == 1) begin
        T0 = (ALPHA0_t + ALPHA1_t * Leff) / Leff;
        if ((T0 <= 0.0) || (BETA0_t <= 0.0)) Iii = 0.0;
        else begin
            T1 = -BETA0_t / (diffVds + 1.0000000000000001e-30);
            _argR169_1_ = T1;
            begin : lexpE169
                real lexp;
                real x_f1;

                x_f1 = _argR169_1_;
                if (x_f1 > 80.0) begin
                    lexp = 5.540622384000e+34 * (1.0 + x_f1 - 80.0);
                end
                else if (x_f1 < -80.0) begin
                    lexp = 1.804851387e-35;
                end
                else begin
                    lexp = exp(x_f1);
                end
                lexpE169 = lexp;
            end
            Iii = T0 * diffVds * ids * lexpE169;
        end
    end
    else if (IIMOD == 2) begin
        ALPHAII = (ALPHAII0_t + ALPHAII1_t * Leff) / Leff;
        if (ALPHAII <= 0.0) begin
            Iii = 0.0;
        end
        else begin
            T0 = ESATII_i * Leff;
            T1 = SII0_t * T0 / (1.0 + T0);
            _argR170_1_ = SII1_i * vgsfbeff;
            _argR170_2_ = IIMOD2CLAMP1;
            begin : hypsmoothE170
                real hypsmooth;
                real x_f3, c_f3;

                x_f3 = _argR170_1_;
                c_f3 = _argR170_2_;
                hypsmooth = 0.5 * (x_f3 + sqrt(x_f3 * x_f3 + 4.0 * c_f3 * c_f3));
                hypsmoothE170 = hypsmooth;
            end
            T0 = 1.0 / (1.0 + hypsmoothE170);
            T3 = T0 + SII2_i;
            _argR171_1_ = vgsfbeff * T3;
            _argR171_2_ = IIMOD2CLAMP2;
            begin : hypsmoothE171
                real hypsmooth;
                real x_f3, c_f3;

                x_f3 = _argR171_1_;
                c_f3 = _argR171_2_;
                hypsmooth = 0.5 * (x_f3 + sqrt(x_f3 * x_f3 + 4.0 * c_f3 * c_f3));
                hypsmoothE171 = hypsmooth;
            end
            T2 = hypsmoothE171;
            T3 = 1.0 / (1.0 + SIID_i * vds);
            VgsStep = T1 * T2 * T3;
            Vdsatii = VgsStep * (1.0 - LII_i / Leff);
            Vdiff = vds - Vdsatii;
            T0 = BETAII2_i + BETAII1_i * Vdiff + BETAII0_i * Vdiff * Vdiff;
            T1 = sqrt(T0 * T0 + 1e-10);
            _argR172_1_ = Vdiff / T1;
            begin : lexpE172
                real lexp;
                real x_f1;

                x_f1 = _argR172_1_;
                if (x_f1 > 80.0) begin
                    lexp = 5.540622384000e+34 * (1.0 + x_f1 - 80.0);
                end
                else if (x_f1 < -80.0) begin
                    lexp = 1.804851387e-35;
                end
                else begin
                    lexp = exp(x_f1);
                end
                lexpE172 = lexp;
            end
            _argR173_1_ = -ALPHAII * lexpE172;
            _argR173_2_ = -10.0;
            _argR173_3_ = IIMOD2CLAMP3;
            begin : hypmaxE173
                real hypmax;
                real x_f4, xmin_f4, c_f4;

                x_f4 = _argR173_1_;
                xmin_f4 = _argR173_2_;
                c_f4 = _argR173_3_;
                hypmax = xmin_f4 + 0.5 * (x_f4 - xmin_f4 - c_f4 + sqrt((x_f4 - xmin_f4 - c_f4) * (x_f4 - xmin_f4 - c_f4) - 4.0 * xmin_f4 * c_f4));
                hypmaxE173 = hypmax;
            end
            Ratio = -hypmaxE173;
            Iii = Ratio * ids;
        end
    end
    igbinv = 0.0;
    igbacc = 0.0;
    igcs = 0.0;
    igcd = 0.0;
    igs = 0.0;
    igd = 0.0;
    if (IGBMOD != 0) begin
        T1 = (qia - EIGBINV_i) / NIGBINV_i / Vtm;
        _argR174_1_ = T1;
        begin : lexpE174
            real lexp;
            real x_f1;

            x_f1 = _argR174_1_;
            if (x_f1 > 80.0) begin
                lexp = 5.540622384000e+34 * (1.0 + x_f1 - 80.0);
            end
            else if (x_f1 < -80.0) begin
                lexp = 1.804851387e-35;
            end
            else begin
                lexp = exp(x_f1);
            end
            lexpE174 = lexp;
        end
        _argR175_1_ = 1.0 + lexpE174;
        begin : llnE175
            real lln;
            real x_f2;

            x_f2 = _argR175_1_;
            lln = ln(max(x_f2,9.9999999999999996e-39));
            llnE175 = lln;
        end
        Vaux_Igbinv = NIGBINV_i * Vtm * llnE175;
        T2 = AIGBINV_t - BIGBINV_i * qia;
        T3 = 1.0 + CIGBINV_i * qia;
        T4 = -9.822220000000e+11 * TOXG * T2 * T3;
        _argR176_1_ = T4;
        begin : lexpE176
            real lexp;
            real x_f1;

            x_f1 = _argR176_1_;
            if (x_f1 > 80.0) begin
                lexp = 5.540622384000e+34 * (1.0 + x_f1 - 80.0);
            end
            else if (x_f1 < -80.0) begin
                lexp = 1.804851387e-35;
            end
            else begin
                lexp = exp(x_f1);
            end
            lexpE176 = lexp;
        end
        T5 = lexpE176;
        T6 = 3.75956e-07;
        igbinv = Weff0 * Leff * T6 * Toxratio * vge * Vaux_Igbinv * T5;
        igbinv = igbinv * igtemp;
        vfbzb = deltaPhi - (Eg / 2.0) - phib;
        T0 = vfbzb - vge;
        T1 = T0 / NIGBACC_i / Vtm;
        _argR177_1_ = T1;
        begin : lexpE177
            real lexp;
            real x_f1;

            x_f1 = _argR177_1_;
            if (x_f1 > 80.0) begin
                lexp = 5.540622384000e+34 * (1.0 + x_f1 - 80.0);
            end
            else if (x_f1 < -80.0) begin
                lexp = 1.804851387e-35;
            end
            else begin
                lexp = exp(x_f1);
            end
            lexpE177 = lexp;
        end
        _argR178_1_ = 1.0 + lexpE177;
        begin : llnE178
            real lln;
            real x_f2;

            x_f2 = _argR178_1_;
            lln = ln(max(x_f2,9.9999999999999996e-39));
            llnE178 = lln;
        end
        Vaux_Igbacc = NIGBACC_i * Vtm * llnE178;
        if (BULKMOD != 0) begin
            Voxacc = qi_acc_for_QM;
        end
        else begin
            if (vfbzb <= 0) Voxacc = 0.5 * (T0 - 0.02 + sqrt((T0 - 0.02) * (T0 - 0.02) - 0.08 * vfbzb));
            else Voxacc = 0.5 * (T0 - 0.02 + sqrt((T0 - 0.02) * (T0 - 0.02) + 0.08 * vfbzb));
        end
        T2 = AIGBACC_t - BIGBACC_i * Voxacc;
        T3 = 1.0 + CIGBACC_i * Voxacc;
        T4 = -7.456690000000e+11 * TOXG * T2 * T3;
        _argR179_1_ = T4;
        begin : lexpE179
            real lexp;
            real x_f1;

            x_f1 = _argR179_1_;
            if (x_f1 > 80.0) begin
                lexp = 5.540622384000e+34 * (1.0 + x_f1 - 80.0);
            end
            else if (x_f1 < -80.0) begin
                lexp = 1.804851387e-35;
            end
            else begin
                lexp = exp(x_f1);
            end
            lexpE179 = lexp;
        end
        T5 = lexpE179;
        T6 = 4.97232e-07;
        igbacc = Weff0 * Leff * T6 * Toxratio * vge * Vaux_Igbacc * T5;
        igbacc = igbacc * igtemp;
    end
    if (IGCMOD != 0) begin
        T1 = AIGC_t - BIGC_i * qia;
        T2 = 1.0 + CIGC_i * qia;
        T3 = -Bechvb * TOXG * T1 * T2;
        _argR180_1_ = T3;
        begin : lexpE180
            real lexp;
            real x_f1;

            x_f1 = _argR180_1_;
            if (x_f1 > 80.0) begin
                lexp = 5.540622384000e+34 * (1.0 + x_f1 - 80.0);
            end
            else if (x_f1 < -80.0) begin
                lexp = 1.804851387e-35;
            end
            else begin
                lexp = exp(x_f1);
            end
            lexpE180 = lexp;
        end
        T4 = qia * lexpE180;
        T5 = (vge + 0.5 * vdsx + 0.5 * (ves_jct + ved_jct));
        igc0 = Weff0 * Leff * Aechvb * Toxratio * T4 * T5 * igtemp;
        Vdseffx = sqrt(Vdseff * Vdseff + 0.01) - 0.1;
        T1 = PIGCD_i * Vdseffx;
        _argR181_1_ = -T1;
        begin : lexpE181
            real lexp;
            real x_f1;

            x_f1 = _argR181_1_;
            if (x_f1 > 80.0) begin
                lexp = 5.540622384000e+34 * (1.0 + x_f1 - 80.0);
            end
            else if (x_f1 < -80.0) begin
                lexp = 1.804851387e-35;
            end
            else begin
                lexp = exp(x_f1);
            end
            lexpE181 = lexp;
        end
        T1_exp = lexpE181;
        T3 = T1 + T1_exp - 1.0 + 0.0001;
        T4 = 1.0 - (T1 + 1.0) * T1_exp + 0.0001;
        T5 = T1 * T1 + 0.0002;
        igcd = igc0 * T4 / T5;
        igcs = igc0 * T3 / T5;
        T0 = vgs_noswap - vfbsd;
        vgs_eff = sqrt(T0 * T0 + 0.0001);
        if (IGCLAMP == 1) begin
            _argR182_1_ = (AIGS_t - BIGS_i * vgs_eff);
            _argR182_2_ = 1e-06;
            begin : hypsmoothE182
                real hypsmooth;
                real x_f3, c_f3;

                x_f3 = _argR182_1_;
                c_f3 = _argR182_2_;
                hypsmooth = 0.5 * (x_f3 + sqrt(x_f3 * x_f3 + 4.0 * c_f3 * c_f3));
                hypsmoothE182 = hypsmooth;
            end
            T1 = hypsmoothE182;
            if (CIGS_i < 0.01) begin
                CIGS_i = 0.01;
            end
        end
        else begin
            T1 = AIGS_t - BIGS_i * vgs_eff;
        end
        T2 = 1.0 + CIGS_i * vgs_eff;
        T3 = -Bechvb * TOXG * POXEDGE_i * T1 * T2;
        _argR183_1_ = T3;
        begin : lexpE183
            real lexp;
            real x_f1;

            x_f1 = _argR183_1_;
            if (x_f1 > 80.0) begin
                lexp = 5.540622384000e+34 * (1.0 + x_f1 - 80.0);
            end
            else if (x_f1 < -80.0) begin
                lexp = 1.804851387e-35;
            end
            else begin
                lexp = exp(x_f1);
            end
            lexpE183 = lexp;
        end
        T4 = lexpE183;
        if (sigvds > 0.0) begin
            igs = igsd_mult * DLCIGS * vgs_noswap * vgs_eff * T4;
        end
        else begin
            igd = igsd_mult * DLCIGS * vgs_noswap * vgs_eff * T4;
        end
        T0 = vgd_noswap - vfbsd;
        vgd_eff = sqrt(T0 * T0 + 0.0001);
        if (IGCLAMP == 1) begin
            _argR184_1_ = (AIGD_t - BIGD_i * vgd_eff);
            _argR184_2_ = 1e-06;
            begin : hypsmoothE184
                real hypsmooth;
                real x_f3, c_f3;

                x_f3 = _argR184_1_;
                c_f3 = _argR184_2_;
                hypsmooth = 0.5 * (x_f3 + sqrt(x_f3 * x_f3 + 4.0 * c_f3 * c_f3));
                hypsmoothE184 = hypsmooth;
            end
            T1 = hypsmoothE184;
            if (CIGD_i < 0.01) begin
                CIGD_i = 0.01;
            end
        end
        else begin
            T1 = AIGD_t - BIGD_i * vgd_eff;
        end
        T2 = 1.0 + CIGD_i * vgd_eff;
        T3 = -Bechvb * TOXG * POXEDGE_i * T1 * T2;
        _argR185_1_ = T3;
        begin : lexpE185
            real lexp;
            real x_f1;

            x_f1 = _argR185_1_;
            if (x_f1 > 80.0) begin
                lexp = 5.540622384000e+34 * (1.0 + x_f1 - 80.0);
            end
            else if (x_f1 < -80.0) begin
                lexp = 1.804851387e-35;
            end
            else begin
                lexp = exp(x_f1);
            end
            lexpE185 = lexp;
        end
        T4 = lexpE185;
        if (sigvds > 0.0) begin
            igd = igsd_mult * DLCIGD * vgd_noswap * vgd_eff * T4;
        end
        else begin
            igs = igsd_mult * DLCIGD * vgd_noswap * vgd_eff * T4;
        end
    end
    igisl = 0.0;
    igidl = 0.0;
    if (GIDLMOD != 0) begin
        T0 = epsratio * EOT;
        if ((AGIDL_i <= 0.0) || (BGIDL_t <= 0.0)) begin
            T6 = 0.0;
        end
        else begin
            T1 = (-vgd_noswap - EGIDL_i + vfbsd) / T0;
            _argR186_1_ = T1;
            _argR186_2_ = 0.01;
            begin : hypsmoothE186
                real hypsmooth;
                real x_f3, c_f3;

                x_f3 = _argR186_1_;
                c_f3 = _argR186_2_;
                hypsmooth = 0.5 * (x_f3 + sqrt(x_f3 * x_f3 + 4.0 * c_f3 * c_f3));
                hypsmoothE186 = hypsmooth;
            end
            T1 = hypsmoothE186;
            T2 = BGIDL_t / (T1 + 0.001);
            _argR187_1_ = T1;
            begin : llnE187
                real lln;
                real x_f2;

                x_f2 = _argR187_1_;
                lln = ln(max(x_f2,9.9999999999999996e-39));
                llnE187 = lln;
            end
            _argR188_1_ = PGIDL_i * llnE187;
            begin : lexpE188
                real lexp;
                real x_f1;

                x_f1 = _argR188_1_;
                if (x_f1 > 80.0) begin
                    lexp = 5.540622384000e+34 * (1.0 + x_f1 - 80.0);
                end
                else if (x_f1 < -80.0) begin
                    lexp = 1.804851387e-35;
                end
                else begin
                    lexp = exp(x_f1);
                end
                lexpE188 = lexp;
            end
            T3 = lexpE188;
            if (BULKMOD != 0) begin
                T4 = -ved_jct * ved_jct * ved_jct;
                T4a = CGIDL_i + abs(T4) + 1e-05;
                _argR189_1_ = T4 / T4a;
                _argR189_2_ = 1e-06;
                begin : hypsmoothE189
                    real hypsmooth;
                    real x_f3, c_f3;

                    x_f3 = _argR189_1_;
                    c_f3 = _argR189_2_;
                    hypsmooth = 0.5 * (x_f3 + sqrt(x_f3 * x_f3 + 4.0 * c_f3 * c_f3));
                    hypsmoothE189 = hypsmooth;
                end
                T5 = hypsmoothE189 - 1e-06;
                _argR190_1_ = -T2;
                begin : lexpE190
                    real lexp;
                    real x_f1;

                    x_f1 = _argR190_1_;
                    if (x_f1 > 80.0) begin
                        lexp = 5.540622384000e+34 * (1.0 + x_f1 - 80.0);
                    end
                    else if (x_f1 < -80.0) begin
                        lexp = 1.804851387e-35;
                    end
                    else begin
                        lexp = exp(x_f1);
                    end
                    lexpE190 = lexp;
                end
                T6 = AGIDL_i * Weff0 * T3 * lexpE190 * T5;
            end
            else begin
                _argR191_1_ = -T2;
                begin : lexpE191
                    real lexp;
                    real x_f1;

                    x_f1 = _argR191_1_;
                    if (x_f1 > 80.0) begin
                        lexp = 5.540622384000e+34 * (1.0 + x_f1 - 80.0);
                    end
                    else if (x_f1 < -80.0) begin
                        lexp = 1.804851387e-35;
                    end
                    else begin
                        lexp = exp(x_f1);
                    end
                    lexpE191 = lexp;
                end
                T6 = AGIDL_i * Weff0 * T3 * lexpE191 * vds_noswap;
            end
        end
        if (sigvds > 0.0) begin
            igidl = T6;
        end
        else begin
            igisl = T6;
        end
        if ((AGISL_i <= 0.0) || (BGISL_t <= 0.0)) begin
            T6 = 0.0;
        end
        else begin
            T1 = (-vgs_noswap - EGISL_i + vfbsd) / T0;
            _argR192_1_ = T1;
            _argR192_2_ = 0.01;
            begin : hypsmoothE192
                real hypsmooth;
                real x_f3, c_f3;

                x_f3 = _argR192_1_;
                c_f3 = _argR192_2_;
                hypsmooth = 0.5 * (x_f3 + sqrt(x_f3 * x_f3 + 4.0 * c_f3 * c_f3));
                hypsmoothE192 = hypsmooth;
            end
            T1 = hypsmoothE192;
            T2 = BGISL_t / (T1 + 0.001);
            _argR193_1_ = T1;
            begin : llnE193
                real lln;
                real x_f2;

                x_f2 = _argR193_1_;
                lln = ln(max(x_f2,9.9999999999999996e-39));
                llnE193 = lln;
            end
            _argR194_1_ = PGISL_i * llnE193;
            begin : lexpE194
                real lexp;
                real x_f1;

                x_f1 = _argR194_1_;
                if (x_f1 > 80.0) begin
                    lexp = 5.540622384000e+34 * (1.0 + x_f1 - 80.0);
                end
                else if (x_f1 < -80.0) begin
                    lexp = 1.804851387e-35;
                end
                else begin
                    lexp = exp(x_f1);
                end
                lexpE194 = lexp;
            end
            T3 = lexpE194;
            if (BULKMOD != 0) begin
                T4 = -ves_jct * ves_jct * ves_jct;
                T4a = CGISL_i + abs(T4) + 1e-05;
                _argR195_1_ = T4 / T4a;
                _argR195_2_ = 1e-06;
                begin : hypsmoothE195
                    real hypsmooth;
                    real x_f3, c_f3;

                    x_f3 = _argR195_1_;
                    c_f3 = _argR195_2_;
                    hypsmooth = 0.5 * (x_f3 + sqrt(x_f3 * x_f3 + 4.0 * c_f3 * c_f3));
                    hypsmoothE195 = hypsmooth;
                end
                T5 = hypsmoothE195 - 1e-06;
                _argR196_1_ = -T2;
                begin : lexpE196
                    real lexp;
                    real x_f1;

                    x_f1 = _argR196_1_;
                    if (x_f1 > 80.0) begin
                        lexp = 5.540622384000e+34 * (1.0 + x_f1 - 80.0);
                    end
                    else if (x_f1 < -80.0) begin
                        lexp = 1.804851387e-35;
                    end
                    else begin
                        lexp = exp(x_f1);
                    end
                    lexpE196 = lexp;
                end
                T6 = AGISL_i * Weff0 * T3 * lexpE196 * T5;
            end
            else begin
                _argR197_1_ = -T2;
                begin : lexpE197
                    real lexp;
                    real x_f1;

                    x_f1 = _argR197_1_;
                    if (x_f1 > 80.0) begin
                        lexp = 5.540622384000e+34 * (1.0 + x_f1 - 80.0);
                    end
                    else if (x_f1 < -80.0) begin
                        lexp = 1.804851387e-35;
                    end
                    else begin
                        lexp = exp(x_f1);
                    end
                    lexpE197 = lexp;
                end
                T6 = AGISL_i * Weff0 * T3 * lexpE197 * (-vds_noswap);
            end
        end
        if (sigvds > 0.0) begin
            igisl = T6;
        end
        else begin
            igidl = T6;
        end
    end
    if (BULKMOD != 0) begin
        if (Isbs > 0.0) begin
            if (ves_jct < VjsmRev) begin
                T0 = ves_jct / Nvtms;
                _argR198_1_ = T0;
                begin : lexpE198
                    real lexp;
                    real x_f1;

                    x_f1 = _argR198_1_;
                    if (x_f1 > 80.0) begin
                        lexp = 5.540622384000e+34 * (1.0 + x_f1 - 80.0);
                    end
                    else if (x_f1 < -80.0) begin
                        lexp = 1.804851387e-35;
                    end
                    else begin
                        lexp = exp(x_f1);
                    end
                    lexpE198 = lexp;
                end
                T1 = lexpE198 - 1.0;
                T2 = IVjsmRev + SslpRev * (ves_jct - VjsmRev);
                Ies = T1 * T2;
            end
            else if (ves_jct <= VjsmFwd) begin
                T0 = ves_jct / Nvtms;
                T1 = (BVS + ves_jct) / Nvtms;
                _argR199_1_ = -T1;
                begin : lexpE199
                    real lexp;
                    real x_f1;

                    x_f1 = _argR199_1_;
                    if (x_f1 > 80.0) begin
                        lexp = 5.540622384000e+34 * (1.0 + x_f1 - 80.0);
                    end
                    else if (x_f1 < -80.0) begin
                        lexp = 1.804851387e-35;
                    end
                    else begin
                        lexp = exp(x_f1);
                    end
                    lexpE199 = lexp;
                end
                T2 = lexpE199;
                _argR200_1_ = T0;
                begin : lexpE200
                    real lexp;
                    real x_f1;

                    x_f1 = _argR200_1_;
                    if (x_f1 > 80.0) begin
                        lexp = 5.540622384000e+34 * (1.0 + x_f1 - 80.0);
                    end
                    else if (x_f1 < -80.0) begin
                        lexp = 1.804851387e-35;
                    end
                    else begin
                        lexp = exp(x_f1);
                    end
                    lexpE200 = lexp;
                end
                Ies = Isbs * (lexpE200 + XExpBVS - 1.0 - XJBVS * T2);
            end
            else begin
                Ies = IVjsmFwd + SslpFwd * (ves_jct - VjsmFwd);
            end
        end
        else begin
            Ies = 0.0;
        end
        if (JTSS_t > 0.0) begin
            if ((VTSS - ves_jct) < (VTSS * 0.001)) begin
                T0 = -ves_jct / Vtm0 / NJTS_t;
                _argR201_1_ = T0 * 1000.0;
                begin : lexpE201
                    real lexp;
                    real x_f1;

                    x_f1 = _argR201_1_;
                    if (x_f1 > 80.0) begin
                        lexp = 5.540622384000e+34 * (1.0 + x_f1 - 80.0);
                    end
                    else if (x_f1 < -80.0) begin
                        lexp = 1.804851387e-35;
                    end
                    else begin
                        lexp = exp(x_f1);
                    end
                    lexpE201 = lexp;
                end
                T1 = lexpE201 - 1.0;
                Ies = Ies - ASEJ * JTSS_t * T1;
            end
            else begin
                T0 = -ves_jct / Vtm0 / NJTS_t;
                _argR202_1_ = T0 * VTSS / (VTSS - ves_jct);
                begin : lexpE202
                    real lexp;
                    real x_f1;

                    x_f1 = _argR202_1_;
                    if (x_f1 > 80.0) begin
                        lexp = 5.540622384000e+34 * (1.0 + x_f1 - 80.0);
                    end
                    else if (x_f1 < -80.0) begin
                        lexp = 1.804851387e-35;
                    end
                    else begin
                        lexp = exp(x_f1);
                    end
                    lexpE202 = lexp;
                end
                T1 = lexpE202 - 1.0;
                Ies = Ies - ASEJ * JTSS_t * T1;
            end
        end
        if (JTSSWS_t > 0.0) begin
            if ((VTSSWS - ves_jct) < (VTSSWS * 0.001)) begin
                T0 = -ves_jct / Vtm0 / NJTSSW_t;
                _argR203_1_ = T0 * 1000.0;
                begin : lexpE203
                    real lexp;
                    real x_f1;

                    x_f1 = _argR203_1_;
                    if (x_f1 > 80.0) begin
                        lexp = 5.540622384000e+34 * (1.0 + x_f1 - 80.0);
                    end
                    else if (x_f1 < -80.0) begin
                        lexp = 1.804851387e-35;
                    end
                    else begin
                        lexp = exp(x_f1);
                    end
                    lexpE203 = lexp;
                end
                T1 = lexpE203 - 1.0;
                Ies = Ies - PSEJ * JTSSWS_t * T1;
            end
            else begin
                T0 = -ves_jct / Vtm0 / NJTSSW_t;
                _argR204_1_ = T0 * VTSSWS / (VTSSWS - ves_jct);
                begin : lexpE204
                    real lexp;
                    real x_f1;

                    x_f1 = _argR204_1_;
                    if (x_f1 > 80.0) begin
                        lexp = 5.540622384000e+34 * (1.0 + x_f1 - 80.0);
                    end
                    else if (x_f1 < -80.0) begin
                        lexp = 1.804851387e-35;
                    end
                    else begin
                        lexp = exp(x_f1);
                    end
                    lexpE204 = lexp;
                end
                T1 = lexpE204 - 1.0;
                Ies = Ies - PSEJ * JTSSWS_t * T1;
            end
        end
        if (JTSSWGS_t > 0.0) begin
            if ((VTSSWGS - ves_jct) < (VTSSWGS * 0.001)) begin
                T0 = -ves_jct / Vtm0 / NJTSSWG_t;
                _argR205_1_ = T0 * 1000.0;
                begin : lexpE205
                    real lexp;
                    real x_f1;

                    x_f1 = _argR205_1_;
                    if (x_f1 > 80.0) begin
                        lexp = 5.540622384000e+34 * (1.0 + x_f1 - 80.0);
                    end
                    else if (x_f1 < -80.0) begin
                        lexp = 1.804851387e-35;
                    end
                    else begin
                        lexp = exp(x_f1);
                    end
                    lexpE205 = lexp;
                end
                T1 = lexpE205 - 1.0;
                Ies = Ies - Weff0 * NFINtotal * JTSSWGS_t * T1;
            end
            else begin
                T0 = -ves_jct / Vtm0 / NJTSSWG_t;
                _argR206_1_ = T0 * VTSSWGS / (VTSSWGS - ves_jct);
                begin : lexpE206
                    real lexp;
                    real x_f1;

                    x_f1 = _argR206_1_;
                    if (x_f1 > 80.0) begin
                        lexp = 5.540622384000e+34 * (1.0 + x_f1 - 80.0);
                    end
                    else if (x_f1 < -80.0) begin
                        lexp = 1.804851387e-35;
                    end
                    else begin
                        lexp = exp(x_f1);
                    end
                    lexpE206 = lexp;
                end
                T1 = lexpE206 - 1.0;
                Ies = Ies - Weff0 * NFINtotal * JTSSWGS_t * T1;
            end
        end
        if (Isbd > 0.0) begin
            if (ved_jct < VjdmRev) begin
                T0 = ved_jct / Nvtmd;
                _argR207_1_ = T0;
                begin : lexpE207
                    real lexp;
                    real x_f1;

                    x_f1 = _argR207_1_;
                    if (x_f1 > 80.0) begin
                        lexp = 5.540622384000e+34 * (1.0 + x_f1 - 80.0);
                    end
                    else if (x_f1 < -80.0) begin
                        lexp = 1.804851387e-35;
                    end
                    else begin
                        lexp = exp(x_f1);
                    end
                    lexpE207 = lexp;
                end
                T1 = lexpE207 - 1.0;
                T2 = IVjdmRev + DslpRev * (ved_jct - VjdmRev);
                Ied = T1 * T2;
            end
            else if (ved_jct <= VjdmFwd) begin
                T0 = ved_jct / Nvtmd;
                T1 = (BVD + ved_jct) / Nvtmd;
                _argR208_1_ = -T1;
                begin : lexpE208
                    real lexp;
                    real x_f1;

                    x_f1 = _argR208_1_;
                    if (x_f1 > 80.0) begin
                        lexp = 5.540622384000e+34 * (1.0 + x_f1 - 80.0);
                    end
                    else if (x_f1 < -80.0) begin
                        lexp = 1.804851387e-35;
                    end
                    else begin
                        lexp = exp(x_f1);
                    end
                    lexpE208 = lexp;
                end
                T2 = lexpE208;
                _argR209_1_ = T0;
                begin : lexpE209
                    real lexp;
                    real x_f1;

                    x_f1 = _argR209_1_;
                    if (x_f1 > 80.0) begin
                        lexp = 5.540622384000e+34 * (1.0 + x_f1 - 80.0);
                    end
                    else if (x_f1 < -80.0) begin
                        lexp = 1.804851387e-35;
                    end
                    else begin
                        lexp = exp(x_f1);
                    end
                    lexpE209 = lexp;
                end
                Ied = Isbd * (lexpE209 + XExpBVD - 1.0 - XJBVD * T2);
            end
            else Ied = IVjdmFwd + DslpFwd * (ved_jct - VjdmFwd);
        end
        else Ied = 0.0;
        if (JTSD_t > 0.0) begin
            if ((VTSD - ved_jct) < (VTSD * 0.001)) begin
                T0 = -ved_jct / Vtm0 / NJTSD_t;
                _argR210_1_ = T0 * 1000.0;
                begin : lexpE210
                    real lexp;
                    real x_f1;

                    x_f1 = _argR210_1_;
                    if (x_f1 > 80.0) begin
                        lexp = 5.540622384000e+34 * (1.0 + x_f1 - 80.0);
                    end
                    else if (x_f1 < -80.0) begin
                        lexp = 1.804851387e-35;
                    end
                    else begin
                        lexp = exp(x_f1);
                    end
                    lexpE210 = lexp;
                end
                T1 = lexpE210 - 1.0;
                Ied = Ied - ADEJ * JTSD_t * T1;
            end
            else begin
                T0 = -ved_jct / Vtm0 / NJTSD_t;
                _argR211_1_ = T0 * VTSD / (VTSD - ved_jct);
                begin : lexpE211
                    real lexp;
                    real x_f1;

                    x_f1 = _argR211_1_;
                    if (x_f1 > 80.0) begin
                        lexp = 5.540622384000e+34 * (1.0 + x_f1 - 80.0);
                    end
                    else if (x_f1 < -80.0) begin
                        lexp = 1.804851387e-35;
                    end
                    else begin
                        lexp = exp(x_f1);
                    end
                    lexpE211 = lexp;
                end
                T1 = lexpE211 - 1.0;
                Ied = Ied - ADEJ * JTSD_t * T1;
            end
        end
        if (JTSSWD_t > 0.0) begin
            if ((VTSSWD - ved_jct) < (VTSSWD * 0.001)) begin
                T0 = -ved_jct / Vtm0 / NJTSSWD_t;
                _argR212_1_ = T0 * 1000.0;
                begin : lexpE212
                    real lexp;
                    real x_f1;

                    x_f1 = _argR212_1_;
                    if (x_f1 > 80.0) begin
                        lexp = 5.540622384000e+34 * (1.0 + x_f1 - 80.0);
                    end
                    else if (x_f1 < -80.0) begin
                        lexp = 1.804851387e-35;
                    end
                    else begin
                        lexp = exp(x_f1);
                    end
                    lexpE212 = lexp;
                end
                T1 = lexpE212 - 1.0;
                Ied = Ied - PDEJ * JTSSWD_t * T1;
            end
            else begin
                T0 = -ved_jct / Vtm0 / NJTSSWD_t;
                _argR213_1_ = T0 * VTSSWD / (VTSSWD - ved_jct);
                begin : lexpE213
                    real lexp;
                    real x_f1;

                    x_f1 = _argR213_1_;
                    if (x_f1 > 80.0) begin
                        lexp = 5.540622384000e+34 * (1.0 + x_f1 - 80.0);
                    end
                    else if (x_f1 < -80.0) begin
                        lexp = 1.804851387e-35;
                    end
                    else begin
                        lexp = exp(x_f1);
                    end
                    lexpE213 = lexp;
                end
                T1 = lexpE213 - 1.0;
                Ied = Ied - PDEJ * JTSSWD_t * T1;
            end
        end
        if (JTSSWGD_t > 0.0) begin
            if ((VTSSWGD - ved_jct) < (VTSSWGD * 0.001)) begin
                T0 = -ved_jct / Vtm0 / NJTSSWGD_t;
                _argR214_1_ = T0 * 1000.0;
                begin : lexpE214
                    real lexp;
                    real x_f1;

                    x_f1 = _argR214_1_;
                    if (x_f1 > 80.0) begin
                        lexp = 5.540622384000e+34 * (1.0 + x_f1 - 80.0);
                    end
                    else if (x_f1 < -80.0) begin
                        lexp = 1.804851387e-35;
                    end
                    else begin
                        lexp = exp(x_f1);
                    end
                    lexpE214 = lexp;
                end
                T1 = lexpE214 - 1.0;
                Ied = Ied - Weff0 * NFINtotal * JTSSWGD_t * T1;
            end
            else begin
                T0 = -ved_jct / Vtm0 / NJTSSWGD_t;
                _argR215_1_ = T0 * VTSSWGD / (VTSSWGD - ved_jct);
                begin : lexpE215
                    real lexp;
                    real x_f1;

                    x_f1 = _argR215_1_;
                    if (x_f1 > 80.0) begin
                        lexp = 5.540622384000e+34 * (1.0 + x_f1 - 80.0);
                    end
                    else if (x_f1 < -80.0) begin
                        lexp = 1.804851387e-35;
                    end
                    else begin
                        lexp = exp(x_f1);
                    end
                    lexpE215 = lexp;
                end
                T1 = lexpE215 - 1.0;
                Ied = Ied - Weff0 * NFINtotal * JTSSWGD_t * T1;
            end
        end
        begin
            if (Czbs > 0.0) begin
                T1 = ves_jct / PBS_t;
                if (T1 < 0.9) begin
                    if (SJS > 0.0) begin
                        _argR216_1_ = 1.0 / SJS;
                        begin : llnE216
                            real lln;
                            real x_f2;

                            x_f2 = _argR216_1_;
                            lln = ln(max(x_f2,9.9999999999999996e-39));
                            llnE216 = lln;
                        end
                        _argR217_1_ = (1.0 / MJS) * llnE216;
                        begin : lexpE217
                            real lexp;
                            real x_f1;

                            x_f1 = _argR217_1_;
                            if (x_f1 > 80.0) begin
                                lexp = 5.540622384000e+34 * (1.0 + x_f1 - 80.0);
                            end
                            else if (x_f1 < -80.0) begin
                                lexp = 1.804851387e-35;
                            end
                            else begin
                                lexp = exp(x_f1);
                            end
                            lexpE217 = lexp;
                        end
                        vec = PBS_t * (1.0 - lexpE217);
                        _argR218_1_ = 1.0 - vec / PBS_t;
                        begin : llnE218
                            real lln;
                            real x_f2;

                            x_f2 = _argR218_1_;
                            lln = ln(max(x_f2,9.9999999999999996e-39));
                            llnE218 = lln;
                        end
                        _argR219_1_ = -(1.0 + MJS) * llnE218;
                        begin : lexpE219
                            real lexp;
                            real x_f1;

                            x_f1 = _argR219_1_;
                            if (x_f1 > 80.0) begin
                                lexp = 5.540622384000e+34 * (1.0 + x_f1 - 80.0);
                            end
                            else if (x_f1 < -80.0) begin
                                lexp = 1.804851387e-35;
                            end
                            else begin
                                lexp = exp(x_f1);
                            end
                            lexpE219 = lexp;
                        end
                        pb2 = PBS_t * SJS * MJS2 / MJS / lexpE219;
                        if (ves_jct > vec) begin
                            arg = 1.0 - T1;
                            if (MJS == 0.5) sarg = 1.0 / sqrt(arg);
                            else begin
                                _argR220_1_ = arg;
                                begin : llnE220
                                    real lln;
                                    real x_f2;

                                    x_f2 = _argR220_1_;
                                    lln = ln(max(x_f2,9.9999999999999996e-39));
                                    llnE220 = lln;
                                end
                                _argR221_1_ = -MJS * llnE220;
                                begin : lexpE221
                                    real lexp;
                                    real x_f1;

                                    x_f1 = _argR221_1_;
                                    if (x_f1 > 80.0) begin
                                        lexp = 5.540622384000e+34 * (1.0 + x_f1 - 80.0);
                                    end
                                    else if (x_f1 < -80.0) begin
                                        lexp = 1.804851387e-35;
                                    end
                                    else begin
                                        lexp = exp(x_f1);
                                    end
                                    lexpE221 = lexp;
                                end
                                sarg = lexpE221;
                            end
                            Qesj1 = PBS_t * Czbs * (1.0 - arg * sarg) / (1.0 - MJS);
                        end
                        else begin
                            arg = 1.0 - vec / PBS_t;
                            if (MJS == 0.5) sarg = 1.0 / sqrt(arg);
                            else begin
                                _argR222_1_ = arg;
                                begin : llnE222
                                    real lln;
                                    real x_f2;

                                    x_f2 = _argR222_1_;
                                    lln = ln(max(x_f2,9.9999999999999996e-39));
                                    llnE222 = lln;
                                end
                                _argR223_1_ = -MJS * llnE222;
                                begin : lexpE223
                                    real lexp;
                                    real x_f1;

                                    x_f1 = _argR223_1_;
                                    if (x_f1 > 80.0) begin
                                        lexp = 5.540622384000e+34 * (1.0 + x_f1 - 80.0);
                                    end
                                    else if (x_f1 < -80.0) begin
                                        lexp = 1.804851387e-35;
                                    end
                                    else begin
                                        lexp = exp(x_f1);
                                    end
                                    lexpE223 = lexp;
                                end
                                sarg = lexpE223;
                            end
                            Qec = PBS_t * Czbs * (1.0 - arg * sarg) / (1.0 - MJS);
                            arg = 1.0 - (ves_jct - vec) / pb2;
                            if (MJS2 == 0.5) sarg = 1.0 / sqrt(arg);
                            else begin
                                _argR224_1_ = arg;
                                begin : llnE224
                                    real lln;
                                    real x_f2;

                                    x_f2 = _argR224_1_;
                                    lln = ln(max(x_f2,9.9999999999999996e-39));
                                    llnE224 = lln;
                                end
                                _argR225_1_ = -MJS2 * llnE224;
                                begin : lexpE225
                                    real lexp;
                                    real x_f1;

                                    x_f1 = _argR225_1_;
                                    if (x_f1 > 80.0) begin
                                        lexp = 5.540622384000e+34 * (1.0 + x_f1 - 80.0);
                                    end
                                    else if (x_f1 < -80.0) begin
                                        lexp = 1.804851387e-35;
                                    end
                                    else begin
                                        lexp = exp(x_f1);
                                    end
                                    lexpE225 = lexp;
                                end
                                sarg = lexpE225;
                            end
                            Qesj1 = Qec + SJS * pb2 * Czbs * (1.0 - arg * sarg) / (1.0 - MJS2);
                        end
                    end
                    else begin
                        arg = 1.0 - T1;
                        if (MJS == 0.5) sarg = 1.0 / sqrt(arg);
                        else begin
                            _argR226_1_ = arg;
                            begin : llnE226
                                real lln;
                                real x_f2;

                                x_f2 = _argR226_1_;
                                lln = ln(max(x_f2,9.9999999999999996e-39));
                                llnE226 = lln;
                            end
                            _argR227_1_ = -MJS * llnE226;
                            begin : lexpE227
                                real lexp;
                                real x_f1;

                                x_f1 = _argR227_1_;
                                if (x_f1 > 80.0) begin
                                    lexp = 5.540622384000e+34 * (1.0 + x_f1 - 80.0);
                                end
                                else if (x_f1 < -80.0) begin
                                    lexp = 1.804851387e-35;
                                end
                                else begin
                                    lexp = exp(x_f1);
                                end
                                lexpE227 = lexp;
                            end
                            sarg = lexpE227;
                        end
                        Qesj1 = PBS_t * Czbs * (1.0 - arg * sarg) / (1.0 - MJS);
                    end
                end
                else begin
                    _argR228_1_ = -MJS * lln(0.1);
                    begin : lexpE228
                        real lexp;
                        real x_f1;

                        x_f1 = _argR228_1_;
                        if (x_f1 > 80.0) begin
                            lexp = 5.540622384000e+34 * (1.0 + x_f1 - 80.0);
                        end
                        else if (x_f1 < -80.0) begin
                            lexp = 1.804851387e-35;
                        end
                        else begin
                            lexp = exp(x_f1);
                        end
                        lexpE228 = lexp;
                    end
                    T2 = lexpE228;
                    T3 = 1.0 / (1.0 - MJS);
                    T4 = T2 * (T1 - 1.0) * (5.0 * MJS * (T1 - 1.0) + (1.0 + MJS));
                    T5 = T3 * (1.0 - 0.05 * MJS * (1.0 + MJS) * T2);
                    Qesj1 = PBS_t * Czbs * (T4 + T5);
                end
            end
            else begin
                Qesj1 = 0.0;
            end
        end
        begin
            if (Czbssw > 0.0) begin
                T1 = ves_jct / PBSWS_t;
                if (T1 < 0.9) begin
                    if (SJSWS > 0.0) begin
                        _argR229_1_ = 1.0 / SJSWS;
                        begin : llnE229
                            real lln;
                            real x_f2;

                            x_f2 = _argR229_1_;
                            lln = ln(max(x_f2,9.9999999999999996e-39));
                            llnE229 = lln;
                        end
                        _argR230_1_ = (1.0 / MJSWS) * llnE229;
                        begin : lexpE230
                            real lexp;
                            real x_f1;

                            x_f1 = _argR230_1_;
                            if (x_f1 > 80.0) begin
                                lexp = 5.540622384000e+34 * (1.0 + x_f1 - 80.0);
                            end
                            else if (x_f1 < -80.0) begin
                                lexp = 1.804851387e-35;
                            end
                            else begin
                                lexp = exp(x_f1);
                            end
                            lexpE230 = lexp;
                        end
                        vec = PBSWS_t * (1.0 - lexpE230);
                        _argR231_1_ = 1.0 - vec / PBSWS_t;
                        begin : llnE231
                            real lln;
                            real x_f2;

                            x_f2 = _argR231_1_;
                            lln = ln(max(x_f2,9.9999999999999996e-39));
                            llnE231 = lln;
                        end
                        _argR232_1_ = -(1.0 + MJSWS) * llnE231;
                        begin : lexpE232
                            real lexp;
                            real x_f1;

                            x_f1 = _argR232_1_;
                            if (x_f1 > 80.0) begin
                                lexp = 5.540622384000e+34 * (1.0 + x_f1 - 80.0);
                            end
                            else if (x_f1 < -80.0) begin
                                lexp = 1.804851387e-35;
                            end
                            else begin
                                lexp = exp(x_f1);
                            end
                            lexpE232 = lexp;
                        end
                        pb2 = PBSWS_t * SJSWS * MJSWS2 / MJSWS / lexpE232;
                        if (ves_jct > vec) begin
                            arg = 1.0 - T1;
                            if (MJSWS == 0.5) sarg = 1.0 / sqrt(arg);
                            else begin
                                _argR233_1_ = arg;
                                begin : llnE233
                                    real lln;
                                    real x_f2;

                                    x_f2 = _argR233_1_;
                                    lln = ln(max(x_f2,9.9999999999999996e-39));
                                    llnE233 = lln;
                                end
                                _argR234_1_ = -MJSWS * llnE233;
                                begin : lexpE234
                                    real lexp;
                                    real x_f1;

                                    x_f1 = _argR234_1_;
                                    if (x_f1 > 80.0) begin
                                        lexp = 5.540622384000e+34 * (1.0 + x_f1 - 80.0);
                                    end
                                    else if (x_f1 < -80.0) begin
                                        lexp = 1.804851387e-35;
                                    end
                                    else begin
                                        lexp = exp(x_f1);
                                    end
                                    lexpE234 = lexp;
                                end
                                sarg = lexpE234;
                            end
                            Qesj2 = PBSWS_t * Czbssw * (1.0 - arg * sarg) / (1.0 - MJSWS);
                        end
                        else begin
                            arg = 1.0 - vec / PBSWS_t;
                            if (MJSWS == 0.5) sarg = 1.0 / sqrt(arg);
                            else begin
                                _argR235_1_ = arg;
                                begin : llnE235
                                    real lln;
                                    real x_f2;

                                    x_f2 = _argR235_1_;
                                    lln = ln(max(x_f2,9.9999999999999996e-39));
                                    llnE235 = lln;
                                end
                                _argR236_1_ = -MJSWS * llnE235;
                                begin : lexpE236
                                    real lexp;
                                    real x_f1;

                                    x_f1 = _argR236_1_;
                                    if (x_f1 > 80.0) begin
                                        lexp = 5.540622384000e+34 * (1.0 + x_f1 - 80.0);
                                    end
                                    else if (x_f1 < -80.0) begin
                                        lexp = 1.804851387e-35;
                                    end
                                    else begin
                                        lexp = exp(x_f1);
                                    end
                                    lexpE236 = lexp;
                                end
                                sarg = lexpE236;
                            end
                            Qec = PBSWS_t * Czbssw * (1.0 - arg * sarg) / (1.0 - MJSWS);
                            arg = 1.0 - (ves_jct - vec) / pb2;
                            if (MJSWS2 == 0.5) sarg = 1.0 / sqrt(arg);
                            else begin
                                _argR237_1_ = arg;
                                begin : llnE237
                                    real lln;
                                    real x_f2;

                                    x_f2 = _argR237_1_;
                                    lln = ln(max(x_f2,9.9999999999999996e-39));
                                    llnE237 = lln;
                                end
                                _argR238_1_ = -MJSWS2 * llnE237;
                                begin : lexpE238
                                    real lexp;
                                    real x_f1;

                                    x_f1 = _argR238_1_;
                                    if (x_f1 > 80.0) begin
                                        lexp = 5.540622384000e+34 * (1.0 + x_f1 - 80.0);
                                    end
                                    else if (x_f1 < -80.0) begin
                                        lexp = 1.804851387e-35;
                                    end
                                    else begin
                                        lexp = exp(x_f1);
                                    end
                                    lexpE238 = lexp;
                                end
                                sarg = lexpE238;
                            end
                            Qesj2 = Qec + SJSWS * pb2 * Czbssw * (1.0 - arg * sarg) / (1.0 - MJSWS2);
                        end
                    end
                    else begin
                        arg = 1.0 - T1;
                        if (MJSWS == 0.5) sarg = 1.0 / sqrt(arg);
                        else begin
                            _argR239_1_ = arg;
                            begin : llnE239
                                real lln;
                                real x_f2;

                                x_f2 = _argR239_1_;
                                lln = ln(max(x_f2,9.9999999999999996e-39));
                                llnE239 = lln;
                            end
                            _argR240_1_ = -MJSWS * llnE239;
                            begin : lexpE240
                                real lexp;
                                real x_f1;

                                x_f1 = _argR240_1_;
                                if (x_f1 > 80.0) begin
                                    lexp = 5.540622384000e+34 * (1.0 + x_f1 - 80.0);
                                end
                                else if (x_f1 < -80.0) begin
                                    lexp = 1.804851387e-35;
                                end
                                else begin
                                    lexp = exp(x_f1);
                                end
                                lexpE240 = lexp;
                            end
                            sarg = lexpE240;
                        end
                        Qesj2 = PBSWS_t * Czbssw * (1.0 - arg * sarg) / (1.0 - MJSWS);
                    end
                end
                else begin
                    _argR241_1_ = -MJSWS * lln(0.1);
                    begin : lexpE241
                        real lexp;
                        real x_f1;

                        x_f1 = _argR241_1_;
                        if (x_f1 > 80.0) begin
                            lexp = 5.540622384000e+34 * (1.0 + x_f1 - 80.0);
                        end
                        else if (x_f1 < -80.0) begin
                            lexp = 1.804851387e-35;
                        end
                        else begin
                            lexp = exp(x_f1);
                        end
                        lexpE241 = lexp;
                    end
                    T2 = lexpE241;
                    T3 = 1.0 / (1.0 - MJSWS);
                    T4 = T2 * (T1 - 1.0) * (5.0 * MJSWS * (T1 - 1.0) + (1.0 + MJSWS));
                    T5 = T3 * (1.0 - 0.05 * MJSWS * (1.0 + MJSWS) * T2);
                    Qesj2 = PBSWS_t * Czbssw * (T4 + T5);
                end
            end
            else begin
                Qesj2 = 0.0;
            end
        end
        begin
            if (Czbsswg > 0.0) begin
                T1 = ves_jct / PBSWGS_t;
                if (T1 < 0.9) begin
                    if (SJSWGS > 0.0) begin
                        _argR242_1_ = 1.0 / SJSWGS;
                        begin : llnE242
                            real lln;
                            real x_f2;

                            x_f2 = _argR242_1_;
                            lln = ln(max(x_f2,9.9999999999999996e-39));
                            llnE242 = lln;
                        end
                        _argR243_1_ = (1.0 / MJSWGS) * llnE242;
                        begin : lexpE243
                            real lexp;
                            real x_f1;

                            x_f1 = _argR243_1_;
                            if (x_f1 > 80.0) begin
                                lexp = 5.540622384000e+34 * (1.0 + x_f1 - 80.0);
                            end
                            else if (x_f1 < -80.0) begin
                                lexp = 1.804851387e-35;
                            end
                            else begin
                                lexp = exp(x_f1);
                            end
                            lexpE243 = lexp;
                        end
                        vec = PBSWGS_t * (1.0 - lexpE243);
                        _argR244_1_ = 1.0 - vec / PBSWGS_t;
                        begin : llnE244
                            real lln;
                            real x_f2;

                            x_f2 = _argR244_1_;
                            lln = ln(max(x_f2,9.9999999999999996e-39));
                            llnE244 = lln;
                        end
                        _argR245_1_ = -(1.0 + MJSWGS) * llnE244;
                        begin : lexpE245
                            real lexp;
                            real x_f1;

                            x_f1 = _argR245_1_;
                            if (x_f1 > 80.0) begin
                                lexp = 5.540622384000e+34 * (1.0 + x_f1 - 80.0);
                            end
                            else if (x_f1 < -80.0) begin
                                lexp = 1.804851387e-35;
                            end
                            else begin
                                lexp = exp(x_f1);
                            end
                            lexpE245 = lexp;
                        end
                        pb2 = PBSWGS_t * SJSWGS * MJSWGS2 / MJSWGS / lexpE245;
                        if (ves_jct > vec) begin
                            arg = 1.0 - T1;
                            if (MJSWGS == 0.5) sarg = 1.0 / sqrt(arg);
                            else begin
                                _argR246_1_ = arg;
                                begin : llnE246
                                    real lln;
                                    real x_f2;

                                    x_f2 = _argR246_1_;
                                    lln = ln(max(x_f2,9.9999999999999996e-39));
                                    llnE246 = lln;
                                end
                                _argR247_1_ = -MJSWGS * llnE246;
                                begin : lexpE247
                                    real lexp;
                                    real x_f1;

                                    x_f1 = _argR247_1_;
                                    if (x_f1 > 80.0) begin
                                        lexp = 5.540622384000e+34 * (1.0 + x_f1 - 80.0);
                                    end
                                    else if (x_f1 < -80.0) begin
                                        lexp = 1.804851387e-35;
                                    end
                                    else begin
                                        lexp = exp(x_f1);
                                    end
                                    lexpE247 = lexp;
                                end
                                sarg = lexpE247;
                            end
                            Qesj3 = PBSWGS_t * Czbsswg * (1.0 - arg * sarg) / (1.0 - MJSWGS);
                        end
                        else begin
                            arg = 1.0 - vec / PBSWGS_t;
                            if (MJSWGS == 0.5) sarg = 1.0 / sqrt(arg);
                            else begin
                                _argR248_1_ = arg;
                                begin : llnE248
                                    real lln;
                                    real x_f2;

                                    x_f2 = _argR248_1_;
                                    lln = ln(max(x_f2,9.9999999999999996e-39));
                                    llnE248 = lln;
                                end
                                _argR249_1_ = -MJSWGS * llnE248;
                                begin : lexpE249
                                    real lexp;
                                    real x_f1;

                                    x_f1 = _argR249_1_;
                                    if (x_f1 > 80.0) begin
                                        lexp = 5.540622384000e+34 * (1.0 + x_f1 - 80.0);
                                    end
                                    else if (x_f1 < -80.0) begin
                                        lexp = 1.804851387e-35;
                                    end
                                    else begin
                                        lexp = exp(x_f1);
                                    end
                                    lexpE249 = lexp;
                                end
                                sarg = lexpE249;
                            end
                            Qec = PBSWGS_t * Czbsswg * (1.0 - arg * sarg) / (1.0 - MJSWGS);
                            arg = 1.0 - (ves_jct - vec) / pb2;
                            if (MJSWGS2 == 0.5) sarg = 1.0 / sqrt(arg);
                            else begin
                                _argR250_1_ = arg;
                                begin : llnE250
                                    real lln;
                                    real x_f2;

                                    x_f2 = _argR250_1_;
                                    lln = ln(max(x_f2,9.9999999999999996e-39));
                                    llnE250 = lln;
                                end
                                _argR251_1_ = -MJSWGS2 * llnE250;
                                begin : lexpE251
                                    real lexp;
                                    real x_f1;

                                    x_f1 = _argR251_1_;
                                    if (x_f1 > 80.0) begin
                                        lexp = 5.540622384000e+34 * (1.0 + x_f1 - 80.0);
                                    end
                                    else if (x_f1 < -80.0) begin
                                        lexp = 1.804851387e-35;
                                    end
                                    else begin
                                        lexp = exp(x_f1);
                                    end
                                    lexpE251 = lexp;
                                end
                                sarg = lexpE251;
                            end
                            Qesj3 = Qec + SJSWGS * pb2 * Czbsswg * (1.0 - arg * sarg) / (1.0 - MJSWGS2);
                        end
                    end
                    else begin
                        arg = 1.0 - T1;
                        if (MJSWGS == 0.5) sarg = 1.0 / sqrt(arg);
                        else begin
                            _argR252_1_ = arg;
                            begin : llnE252
                                real lln;
                                real x_f2;

                                x_f2 = _argR252_1_;
                                lln = ln(max(x_f2,9.9999999999999996e-39));
                                llnE252 = lln;
                            end
                            _argR253_1_ = -MJSWGS * llnE252;
                            begin : lexpE253
                                real lexp;
                                real x_f1;

                                x_f1 = _argR253_1_;
                                if (x_f1 > 80.0) begin
                                    lexp = 5.540622384000e+34 * (1.0 + x_f1 - 80.0);
                                end
                                else if (x_f1 < -80.0) begin
                                    lexp = 1.804851387e-35;
                                end
                                else begin
                                    lexp = exp(x_f1);
                                end
                                lexpE253 = lexp;
                            end
                            sarg = lexpE253;
                        end
                        Qesj3 = PBSWGS_t * Czbsswg * (1.0 - arg * sarg) / (1.0 - MJSWGS);
                    end
                end
                else begin
                    _argR254_1_ = -MJSWGS * lln(0.1);
                    begin : lexpE254
                        real lexp;
                        real x_f1;

                        x_f1 = _argR254_1_;
                        if (x_f1 > 80.0) begin
                            lexp = 5.540622384000e+34 * (1.0 + x_f1 - 80.0);
                        end
                        else if (x_f1 < -80.0) begin
                            lexp = 1.804851387e-35;
                        end
                        else begin
                            lexp = exp(x_f1);
                        end
                        lexpE254 = lexp;
                    end
                    T2 = lexpE254;
                    T3 = 1.0 / (1.0 - MJSWGS);
                    T4 = T2 * (T1 - 1.0) * (5.0 * MJSWGS * (T1 - 1.0) + (1.0 + MJSWGS));
                    T5 = T3 * (1.0 - 0.05 * MJSWGS * (1.0 + MJSWGS) * T2);
                    Qesj3 = PBSWGS_t * Czbsswg * (T4 + T5);
                end
            end
            else begin
                Qesj3 = 0.0;
            end
        end
        Qesj = Qesj1 + Qesj2 + Qesj3;
        begin
            if (Czbd > 0.0) begin
                T1 = ved_jct / PBD_t;
                if (T1 < 0.9) begin
                    if (SJD > 0.0) begin
                        _argR255_1_ = 1.0 / SJD;
                        begin : llnE255
                            real lln;
                            real x_f2;

                            x_f2 = _argR255_1_;
                            lln = ln(max(x_f2,9.9999999999999996e-39));
                            llnE255 = lln;
                        end
                        _argR256_1_ = (1.0 / MJD) * llnE255;
                        begin : lexpE256
                            real lexp;
                            real x_f1;

                            x_f1 = _argR256_1_;
                            if (x_f1 > 80.0) begin
                                lexp = 5.540622384000e+34 * (1.0 + x_f1 - 80.0);
                            end
                            else if (x_f1 < -80.0) begin
                                lexp = 1.804851387e-35;
                            end
                            else begin
                                lexp = exp(x_f1);
                            end
                            lexpE256 = lexp;
                        end
                        vec = PBD_t * (1.0 - lexpE256);
                        _argR257_1_ = 1.0 - vec / PBD_t;
                        begin : llnE257
                            real lln;
                            real x_f2;

                            x_f2 = _argR257_1_;
                            lln = ln(max(x_f2,9.9999999999999996e-39));
                            llnE257 = lln;
                        end
                        _argR258_1_ = -(1.0 + MJD) * llnE257;
                        begin : lexpE258
                            real lexp;
                            real x_f1;

                            x_f1 = _argR258_1_;
                            if (x_f1 > 80.0) begin
                                lexp = 5.540622384000e+34 * (1.0 + x_f1 - 80.0);
                            end
                            else if (x_f1 < -80.0) begin
                                lexp = 1.804851387e-35;
                            end
                            else begin
                                lexp = exp(x_f1);
                            end
                            lexpE258 = lexp;
                        end
                        pb2 = PBD_t * SJD * MJD2 / MJD / lexpE258;
                        if (ved_jct > vec) begin
                            arg = 1.0 - T1;
                            if (MJD == 0.5) sarg = 1.0 / sqrt(arg);
                            else begin
                                _argR259_1_ = arg;
                                begin : llnE259
                                    real lln;
                                    real x_f2;

                                    x_f2 = _argR259_1_;
                                    lln = ln(max(x_f2,9.9999999999999996e-39));
                                    llnE259 = lln;
                                end
                                _argR260_1_ = -MJD * llnE259;
                                begin : lexpE260
                                    real lexp;
                                    real x_f1;

                                    x_f1 = _argR260_1_;
                                    if (x_f1 > 80.0) begin
                                        lexp = 5.540622384000e+34 * (1.0 + x_f1 - 80.0);
                                    end
                                    else if (x_f1 < -80.0) begin
                                        lexp = 1.804851387e-35;
                                    end
                                    else begin
                                        lexp = exp(x_f1);
                                    end
                                    lexpE260 = lexp;
                                end
                                sarg = lexpE260;
                            end
                            Qedj1 = PBD_t * Czbd * (1.0 - arg * sarg) / (1.0 - MJD);
                        end
                        else begin
                            arg = 1.0 - vec / PBD_t;
                            if (MJD == 0.5) sarg = 1.0 / sqrt(arg);
                            else begin
                                _argR261_1_ = arg;
                                begin : llnE261
                                    real lln;
                                    real x_f2;

                                    x_f2 = _argR261_1_;
                                    lln = ln(max(x_f2,9.9999999999999996e-39));
                                    llnE261 = lln;
                                end
                                _argR262_1_ = -MJD * llnE261;
                                begin : lexpE262
                                    real lexp;
                                    real x_f1;

                                    x_f1 = _argR262_1_;
                                    if (x_f1 > 80.0) begin
                                        lexp = 5.540622384000e+34 * (1.0 + x_f1 - 80.0);
                                    end
                                    else if (x_f1 < -80.0) begin
                                        lexp = 1.804851387e-35;
                                    end
                                    else begin
                                        lexp = exp(x_f1);
                                    end
                                    lexpE262 = lexp;
                                end
                                sarg = lexpE262;
                            end
                            Qec = PBD_t * Czbd * (1.0 - arg * sarg) / (1.0 - MJD);
                            arg = 1.0 - (ved_jct - vec) / pb2;
                            if (MJD2 == 0.5) sarg = 1.0 / sqrt(arg);
                            else begin
                                _argR263_1_ = arg;
                                begin : llnE263
                                    real lln;
                                    real x_f2;

                                    x_f2 = _argR263_1_;
                                    lln = ln(max(x_f2,9.9999999999999996e-39));
                                    llnE263 = lln;
                                end
                                _argR264_1_ = -MJD2 * llnE263;
                                begin : lexpE264
                                    real lexp;
                                    real x_f1;

                                    x_f1 = _argR264_1_;
                                    if (x_f1 > 80.0) begin
                                        lexp = 5.540622384000e+34 * (1.0 + x_f1 - 80.0);
                                    end
                                    else if (x_f1 < -80.0) begin
                                        lexp = 1.804851387e-35;
                                    end
                                    else begin
                                        lexp = exp(x_f1);
                                    end
                                    lexpE264 = lexp;
                                end
                                sarg = lexpE264;
                            end
                            Qedj1 = Qec + SJD * pb2 * Czbd * (1.0 - arg * sarg) / (1.0 - MJD2);
                        end
                    end
                    else begin
                        arg = 1.0 - T1;
                        if (MJD == 0.5) sarg = 1.0 / sqrt(arg);
                        else begin
                            _argR265_1_ = arg;
                            begin : llnE265
                                real lln;
                                real x_f2;

                                x_f2 = _argR265_1_;
                                lln = ln(max(x_f2,9.9999999999999996e-39));
                                llnE265 = lln;
                            end
                            _argR266_1_ = -MJD * llnE265;
                            begin : lexpE266
                                real lexp;
                                real x_f1;

                                x_f1 = _argR266_1_;
                                if (x_f1 > 80.0) begin
                                    lexp = 5.540622384000e+34 * (1.0 + x_f1 - 80.0);
                                end
                                else if (x_f1 < -80.0) begin
                                    lexp = 1.804851387e-35;
                                end
                                else begin
                                    lexp = exp(x_f1);
                                end
                                lexpE266 = lexp;
                            end
                            sarg = lexpE266;
                        end
                        Qedj1 = PBD_t * Czbd * (1.0 - arg * sarg) / (1.0 - MJD);
                    end
                end
                else begin
                    _argR267_1_ = -MJD * lln(0.1);
                    begin : lexpE267
                        real lexp;
                        real x_f1;

                        x_f1 = _argR267_1_;
                        if (x_f1 > 80.0) begin
                            lexp = 5.540622384000e+34 * (1.0 + x_f1 - 80.0);
                        end
                        else if (x_f1 < -80.0) begin
                            lexp = 1.804851387e-35;
                        end
                        else begin
                            lexp = exp(x_f1);
                        end
                        lexpE267 = lexp;
                    end
                    T2 = lexpE267;
                    T3 = 1.0 / (1.0 - MJD);
                    T4 = T2 * (T1 - 1.0) * (5.0 * MJD * (T1 - 1.0) + (1.0 + MJD));
                    T5 = T3 * (1.0 - 0.05 * MJD * (1.0 + MJD) * T2);
                    Qedj1 = PBD_t * Czbd * (T4 + T5);
                end
            end
            else begin
                Qedj1 = 0.0;
            end
        end
        begin
            if (Czbdsw > 0.0) begin
                T1 = ved_jct / PBSWD_t;
                if (T1 < 0.9) begin
                    if (SJSWD > 0.0) begin
                        _argR268_1_ = 1.0 / SJSWD;
                        begin : llnE268
                            real lln;
                            real x_f2;

                            x_f2 = _argR268_1_;
                            lln = ln(max(x_f2,9.9999999999999996e-39));
                            llnE268 = lln;
                        end
                        _argR269_1_ = (1.0 / MJSWD) * llnE268;
                        begin : lexpE269
                            real lexp;
                            real x_f1;

                            x_f1 = _argR269_1_;
                            if (x_f1 > 80.0) begin
                                lexp = 5.540622384000e+34 * (1.0 + x_f1 - 80.0);
                            end
                            else if (x_f1 < -80.0) begin
                                lexp = 1.804851387e-35;
                            end
                            else begin
                                lexp = exp(x_f1);
                            end
                            lexpE269 = lexp;
                        end
                        vec = PBSWD_t * (1.0 - lexpE269);
                        _argR270_1_ = 1.0 - vec / PBSWD_t;
                        begin : llnE270
                            real lln;
                            real x_f2;

                            x_f2 = _argR270_1_;
                            lln = ln(max(x_f2,9.9999999999999996e-39));
                            llnE270 = lln;
                        end
                        _argR271_1_ = -(1.0 + MJSWD) * llnE270;
                        begin : lexpE271
                            real lexp;
                            real x_f1;

                            x_f1 = _argR271_1_;
                            if (x_f1 > 80.0) begin
                                lexp = 5.540622384000e+34 * (1.0 + x_f1 - 80.0);
                            end
                            else if (x_f1 < -80.0) begin
                                lexp = 1.804851387e-35;
                            end
                            else begin
                                lexp = exp(x_f1);
                            end
                            lexpE271 = lexp;
                        end
                        pb2 = PBSWD_t * SJSWD * MJSWD2 / MJSWD / lexpE271;
                        if (ved_jct > vec) begin
                            arg = 1.0 - T1;
                            if (MJSWD == 0.5) sarg = 1.0 / sqrt(arg);
                            else begin
                                _argR272_1_ = arg;
                                begin : llnE272
                                    real lln;
                                    real x_f2;

                                    x_f2 = _argR272_1_;
                                    lln = ln(max(x_f2,9.9999999999999996e-39));
                                    llnE272 = lln;
                                end
                                _argR273_1_ = -MJSWD * llnE272;
                                begin : lexpE273
                                    real lexp;
                                    real x_f1;

                                    x_f1 = _argR273_1_;
                                    if (x_f1 > 80.0) begin
                                        lexp = 5.540622384000e+34 * (1.0 + x_f1 - 80.0);
                                    end
                                    else if (x_f1 < -80.0) begin
                                        lexp = 1.804851387e-35;
                                    end
                                    else begin
                                        lexp = exp(x_f1);
                                    end
                                    lexpE273 = lexp;
                                end
                                sarg = lexpE273;
                            end
                            Qedj2 = PBSWD_t * Czbdsw * (1.0 - arg * sarg) / (1.0 - MJSWD);
                        end
                        else begin
                            arg = 1.0 - vec / PBSWD_t;
                            if (MJSWD == 0.5) sarg = 1.0 / sqrt(arg);
                            else begin
                                _argR274_1_ = arg;
                                begin : llnE274
                                    real lln;
                                    real x_f2;

                                    x_f2 = _argR274_1_;
                                    lln = ln(max(x_f2,9.9999999999999996e-39));
                                    llnE274 = lln;
                                end
                                _argR275_1_ = -MJSWD * llnE274;
                                begin : lexpE275
                                    real lexp;
                                    real x_f1;

                                    x_f1 = _argR275_1_;
                                    if (x_f1 > 80.0) begin
                                        lexp = 5.540622384000e+34 * (1.0 + x_f1 - 80.0);
                                    end
                                    else if (x_f1 < -80.0) begin
                                        lexp = 1.804851387e-35;
                                    end
                                    else begin
                                        lexp = exp(x_f1);
                                    end
                                    lexpE275 = lexp;
                                end
                                sarg = lexpE275;
                            end
                            Qec = PBSWD_t * Czbdsw * (1.0 - arg * sarg) / (1.0 - MJSWD);
                            arg = 1.0 - (ved_jct - vec) / pb2;
                            if (MJSWD2 == 0.5) sarg = 1.0 / sqrt(arg);
                            else begin
                                _argR276_1_ = arg;
                                begin : llnE276
                                    real lln;
                                    real x_f2;

                                    x_f2 = _argR276_1_;
                                    lln = ln(max(x_f2,9.9999999999999996e-39));
                                    llnE276 = lln;
                                end
                                _argR277_1_ = -MJSWD2 * llnE276;
                                begin : lexpE277
                                    real lexp;
                                    real x_f1;

                                    x_f1 = _argR277_1_;
                                    if (x_f1 > 80.0) begin
                                        lexp = 5.540622384000e+34 * (1.0 + x_f1 - 80.0);
                                    end
                                    else if (x_f1 < -80.0) begin
                                        lexp = 1.804851387e-35;
                                    end
                                    else begin
                                        lexp = exp(x_f1);
                                    end
                                    lexpE277 = lexp;
                                end
                                sarg = lexpE277;
                            end
                            Qedj2 = Qec + SJSWD * pb2 * Czbdsw * (1.0 - arg * sarg) / (1.0 - MJSWD2);
                        end
                    end
                    else begin
                        arg = 1.0 - T1;
                        if (MJSWD == 0.5) sarg = 1.0 / sqrt(arg);
                        else begin
                            _argR278_1_ = arg;
                            begin : llnE278
                                real lln;
                                real x_f2;

                                x_f2 = _argR278_1_;
                                lln = ln(max(x_f2,9.9999999999999996e-39));
                                llnE278 = lln;
                            end
                            _argR279_1_ = -MJSWD * llnE278;
                            begin : lexpE279
                                real lexp;
                                real x_f1;

                                x_f1 = _argR279_1_;
                                if (x_f1 > 80.0) begin
                                    lexp = 5.540622384000e+34 * (1.0 + x_f1 - 80.0);
                                end
                                else if (x_f1 < -80.0) begin
                                    lexp = 1.804851387e-35;
                                end
                                else begin
                                    lexp = exp(x_f1);
                                end
                                lexpE279 = lexp;
                            end
                            sarg = lexpE279;
                        end
                        Qedj2 = PBSWD_t * Czbdsw * (1.0 - arg * sarg) / (1.0 - MJSWD);
                    end
                end
                else begin
                    _argR280_1_ = -MJSWD * lln(0.1);
                    begin : lexpE280
                        real lexp;
                        real x_f1;

                        x_f1 = _argR280_1_;
                        if (x_f1 > 80.0) begin
                            lexp = 5.540622384000e+34 * (1.0 + x_f1 - 80.0);
                        end
                        else if (x_f1 < -80.0) begin
                            lexp = 1.804851387e-35;
                        end
                        else begin
                            lexp = exp(x_f1);
                        end
                        lexpE280 = lexp;
                    end
                    T2 = lexpE280;
                    T3 = 1.0 / (1.0 - MJSWD);
                    T4 = T2 * (T1 - 1.0) * (5.0 * MJSWD * (T1 - 1.0) + (1.0 + MJSWD));
                    T5 = T3 * (1.0 - 0.05 * MJSWD * (1.0 + MJSWD) * T2);
                    Qedj2 = PBSWD_t * Czbdsw * (T4 + T5);
                end
            end
            else begin
                Qedj2 = 0.0;
            end
        end
        begin
            if (Czbdswg > 0.0) begin
                T1 = ved_jct / PBSWGD_t;
                if (T1 < 0.9) begin
                    if (SJSWGD > 0.0) begin
                        _argR281_1_ = 1.0 / SJSWGD;
                        begin : llnE281
                            real lln;
                            real x_f2;

                            x_f2 = _argR281_1_;
                            lln = ln(max(x_f2,9.9999999999999996e-39));
                            llnE281 = lln;
                        end
                        _argR282_1_ = (1.0 / MJSWGD) * llnE281;
                        begin : lexpE282
                            real lexp;
                            real x_f1;

                            x_f1 = _argR282_1_;
                            if (x_f1 > 80.0) begin
                                lexp = 5.540622384000e+34 * (1.0 + x_f1 - 80.0);
                            end
                            else if (x_f1 < -80.0) begin
                                lexp = 1.804851387e-35;
                            end
                            else begin
                                lexp = exp(x_f1);
                            end
                            lexpE282 = lexp;
                        end
                        vec = PBSWGD_t * (1.0 - lexpE282);
                        _argR283_1_ = 1.0 - vec / PBSWGD_t;
                        begin : llnE283
                            real lln;
                            real x_f2;

                            x_f2 = _argR283_1_;
                            lln = ln(max(x_f2,9.9999999999999996e-39));
                            llnE283 = lln;
                        end
                        _argR284_1_ = -(1.0 + MJSWGD) * llnE283;
                        begin : lexpE284
                            real lexp;
                            real x_f1;

                            x_f1 = _argR284_1_;
                            if (x_f1 > 80.0) begin
                                lexp = 5.540622384000e+34 * (1.0 + x_f1 - 80.0);
                            end
                            else if (x_f1 < -80.0) begin
                                lexp = 1.804851387e-35;
                            end
                            else begin
                                lexp = exp(x_f1);
                            end
                            lexpE284 = lexp;
                        end
                        pb2 = PBSWGD_t * SJSWGD * MJSWGD2 / MJSWGD / lexpE284;
                        if (ved_jct > vec) begin
                            arg = 1.0 - T1;
                            if (MJSWGD == 0.5) sarg = 1.0 / sqrt(arg);
                            else begin
                                _argR285_1_ = arg;
                                begin : llnE285
                                    real lln;
                                    real x_f2;

                                    x_f2 = _argR285_1_;
                                    lln = ln(max(x_f2,9.9999999999999996e-39));
                                    llnE285 = lln;
                                end
                                _argR286_1_ = -MJSWGD * llnE285;
                                begin : lexpE286
                                    real lexp;
                                    real x_f1;

                                    x_f1 = _argR286_1_;
                                    if (x_f1 > 80.0) begin
                                        lexp = 5.540622384000e+34 * (1.0 + x_f1 - 80.0);
                                    end
                                    else if (x_f1 < -80.0) begin
                                        lexp = 1.804851387e-35;
                                    end
                                    else begin
                                        lexp = exp(x_f1);
                                    end
                                    lexpE286 = lexp;
                                end
                                sarg = lexpE286;
                            end
                            Qedj3 = PBSWGD_t * Czbdswg * (1.0 - arg * sarg) / (1.0 - MJSWGD);
                        end
                        else begin
                            arg = 1.0 - vec / PBSWGD_t;
                            if (MJSWGD == 0.5) sarg = 1.0 / sqrt(arg);
                            else begin
                                _argR287_1_ = arg;
                                begin : llnE287
                                    real lln;
                                    real x_f2;

                                    x_f2 = _argR287_1_;
                                    lln = ln(max(x_f2,9.9999999999999996e-39));
                                    llnE287 = lln;
                                end
                                _argR288_1_ = -MJSWGD * llnE287;
                                begin : lexpE288
                                    real lexp;
                                    real x_f1;

                                    x_f1 = _argR288_1_;
                                    if (x_f1 > 80.0) begin
                                        lexp = 5.540622384000e+34 * (1.0 + x_f1 - 80.0);
                                    end
                                    else if (x_f1 < -80.0) begin
                                        lexp = 1.804851387e-35;
                                    end
                                    else begin
                                        lexp = exp(x_f1);
                                    end
                                    lexpE288 = lexp;
                                end
                                sarg = lexpE288;
                            end
                            Qec = PBSWGD_t * Czbdswg * (1.0 - arg * sarg) / (1.0 - MJSWGD);
                            arg = 1.0 - (ved_jct - vec) / pb2;
                            if (MJSWGD2 == 0.5) sarg = 1.0 / sqrt(arg);
                            else begin
                                _argR289_1_ = arg;
                                begin : llnE289
                                    real lln;
                                    real x_f2;

                                    x_f2 = _argR289_1_;
                                    lln = ln(max(x_f2,9.9999999999999996e-39));
                                    llnE289 = lln;
                                end
                                _argR290_1_ = -MJSWGD2 * llnE289;
                                begin : lexpE290
                                    real lexp;
                                    real x_f1;

                                    x_f1 = _argR290_1_;
                                    if (x_f1 > 80.0) begin
                                        lexp = 5.540622384000e+34 * (1.0 + x_f1 - 80.0);
                                    end
                                    else if (x_f1 < -80.0) begin
                                        lexp = 1.804851387e-35;
                                    end
                                    else begin
                                        lexp = exp(x_f1);
                                    end
                                    lexpE290 = lexp;
                                end
                                sarg = lexpE290;
                            end
                            Qedj3 = Qec + SJSWGD * pb2 * Czbdswg * (1.0 - arg * sarg) / (1.0 - MJSWGD2);
                        end
                    end
                    else begin
                        arg = 1.0 - T1;
                        if (MJSWGD == 0.5) sarg = 1.0 / sqrt(arg);
                        else begin
                            _argR291_1_ = arg;
                            begin : llnE291
                                real lln;
                                real x_f2;

                                x_f2 = _argR291_1_;
                                lln = ln(max(x_f2,9.9999999999999996e-39));
                                llnE291 = lln;
                            end
                            _argR292_1_ = -MJSWGD * llnE291;
                            begin : lexpE292
                                real lexp;
                                real x_f1;

                                x_f1 = _argR292_1_;
                                if (x_f1 > 80.0) begin
                                    lexp = 5.540622384000e+34 * (1.0 + x_f1 - 80.0);
                                end
                                else if (x_f1 < -80.0) begin
                                    lexp = 1.804851387e-35;
                                end
                                else begin
                                    lexp = exp(x_f1);
                                end
                                lexpE292 = lexp;
                            end
                            sarg = lexpE292;
                        end
                        Qedj3 = PBSWGD_t * Czbdswg * (1.0 - arg * sarg) / (1.0 - MJSWGD);
                    end
                end
                else begin
                    _argR293_1_ = -MJSWGD * lln(0.1);
                    begin : lexpE293
                        real lexp;
                        real x_f1;

                        x_f1 = _argR293_1_;
                        if (x_f1 > 80.0) begin
                            lexp = 5.540622384000e+34 * (1.0 + x_f1 - 80.0);
                        end
                        else if (x_f1 < -80.0) begin
                            lexp = 1.804851387e-35;
                        end
                        else begin
                            lexp = exp(x_f1);
                        end
                        lexpE293 = lexp;
                    end
                    T2 = lexpE293;
                    T3 = 1.0 / (1.0 - MJSWGD);
                    T4 = T2 * (T1 - 1.0) * (5.0 * MJSWGD * (T1 - 1.0) + (1.0 + MJSWGD));
                    T5 = T3 * (1.0 - 0.05 * MJSWGD * (1.0 + MJSWGD) * T2);
                    Qedj3 = PBSWGD_t * Czbdswg * (T4 + T5);
                end
            end
            else begin
                Qedj3 = 0.0;
            end
        end
        Qedj = Qedj1 + Qedj2 + Qedj3;
    end
    Qes = Qesj + csbox * ves_jct;
    Qed = Qedj + cdbox * ved_jct;
    Qeg = cgbox * devsign * V(e,ge);
    if (BULKMOD != 0) begin
        T2 = devsign * V(ge,e);
        T3 = T2 - deltaPhi + Eg / 2.0 + phib - DELVFBACC;
        T0 = T3 + 0.02;
        vge_overlap = 0.5 * (T0 + sqrt(T0 * T0 + 4.0 * 0.02));
        Qeg = Qeg - NFINtotal * LeffCV * (CGBL_i * (T3 - vge_overlap + 0.5 * CKAPPAB_i * (sqrt(1.0 + 4.0 * vge_overlap / CKAPPAB_i) - 1.0)));
    end
    T0 = vds;
    T1 = T0 * (AIGEN_i + BIGEN_i * T0 * T0);
    idsgen = HFIN * TFIN * (Leff - 2.0 * LINTIGEN_i) * igentemp * T1;
    T0 = ueff * coxeff * Weff0 / Leff;
    igidl = NFINtotal * igidl;
    igisl = NFINtotal * igisl;
    igcd = NFINtotal * igcd;
    igcs = NFINtotal * igcs;
    igs = NFINtotal * igs;
    igd = NFINtotal * igd;
    igbinv = NFINtotal * igbinv;
    igbacc = NFINtotal * igbacc;
    idsgen = NFINtotal * idsgen;
    igbs = 0.0;
    igbd = 0.0;
    if (BULKMOD == 0) begin
        igbs = (igbinv + igbacc) * wf;
        igbd = (igbinv + igbacc) * wr;
    end
    Esatnoi = 2.0 * VSAT_a / ueff;
    if (NOIA > 0.0 || NOIB > 0.0 || NOIC > 0.0) begin
        Leffnoi = Leff - 2.0 * LINTNOI_i;
        Leffnoisq = Leffnoi * Leffnoi;
        if (EM <= 0.0) begin
            DelClm = 0.0;
        end
        else begin
            T0 = (diffVds / litl + EM) / Esatnoi;
            _argR294_1_ = T0;
            begin : llnE294
                real lln;
                real x_f2;

                x_f2 = _argR294_1_;
                lln = ln(max(x_f2,9.9999999999999996e-39));
                llnE294 = lln;
            end
            DelClm = litl * llnE294;
            if (DelClm < 0.0) begin
                DelClm = 0.0;
            end
        end
        T1 = 1.6021899999999999e-19 * 1.6021899999999999e-19 * 1.6021899999999999e-19 * Vtm * abs(ids) * ueff;
        T2 = 1.000000000000e+10 * coxeff * Leffnoisq;
        N0 = coxeff * qis / 1.6021899999999999e-19;
        Nl = coxeff * qid / 1.6021899999999999e-19;
        Nstar = Vtm / 1.6021899999999999e-19 * (coxeff + CIT_a);
        _argR295_1_ = (N0 + Nstar) / (Nl + Nstar);
        begin : llnE295
            real lln;
            real x_f2;

            x_f2 = _argR295_1_;
            lln = ln(max(x_f2,9.9999999999999996e-39));
            llnE295 = lln;
        end
        T3 = NOIA * llnE295;
        T4 = NOIB * (N0 - Nl);
        T5 = 0.5 * NOIC * (N0 * N0 - Nl * Nl);
        T6 = 1.6021899999999999e-19 * Vtm * ids * ids;
        T7 = 1.000000000000e+10 * Leffnoisq * Weff0 * NFINtotal;
        T8 = NOIA + NOIB * Nl + NOIC * Nl * Nl;
        T9 = (Nl + Nstar) * (Nl + Nstar);
        Ssi = T1 / T2 * (T3 + T4 + T5) + T6 / T7 * DelClm * T8 / T9;
        T10 = NOIA * 1.6021899999999999e-19 * Vtm;
        T11 = Weff0 * NFINtotal * Leffnoi * 1.000000000000e+10 * Nstar * Nstar;
        Swi = T10 / T11 * ids * ids;
        T1 = Swi + Ssi;
        if (T1 > 0.0) begin
            FNPowerAt1Hz = (Ssi * Swi) / T1;
        end
        else begin
            FNPowerAt1Hz = 0.0;
        end
    end
    else begin
        FNPowerAt1Hz = 0.0;
    end
    case (TNOIMOD)
    0 : begin
        T0 = ueff * qinv;
        T1 = T0 * Rdsi + Leff * Leff;
        Gtnoi = (T0 / T1) * NTNOI_i;
        sid = 4.0 * Vtm * 1.6021899999999999e-19 * Gtnoi;
    end
    1 : begin
        Abulk = 1.0;
        Vgst2Vtm = KSATIV_a * (qis + 2.0 * Vtm);
        etaa = 1.0 - Vdseff * Abulk / Vgst2Vtm;
        T0 = 1.0 - etaa;
        T1 = 1.0 + etaa;
        T2 = T1 + 2.0 * Abulk * Vtm / (qia + 1e-10);
        T3 = T2 * T2;
        T4 = T0 * T0;
        T5 = T3 * T3;
        T6 = 1.0 / (1.0 + Vdseff / EsatL);
        gamma = T6 * (0.5 * T1 + T0 * T0 / (6.0 * T2));
        delta = ((T1 / T3) - (5.0 * T1 + T2) * T4 / (15.0 * T5) + T4 * T4 / (9.0 * T5 * T2)) / (6.0 * T6 * T6 * T6);
        T7 = T0 / T2;
        epsilon = (T7 + T7 * T7 * T7 / 3.0) / (6.0 * T6);
        T8 = qia / EsatL;
        T8 = T8 * T8;
        npart_c = RNOIC * (1.0 + T8 * TNOIC * Leff);
        T9 = gamma * delta;
        if (T9 > 0.0) begin
            ctnoi = epsilon / sqrt(gamma * delta) * (2.5316 * npart_c);
        end
        else begin
            ctnoi = 1.0;
        end
        if (ctnoi > 1) begin
            ctnoi = 1.0;
        end
        if (ctnoi < 0) begin
            ctnoi = 0.0;
        end
        npart_beta = RNOIA * (1.0 + T8 * TNOIA * Leff);
        npart_theta = RNOIB * (1.0 + T8 * TNOIB * Leff);
        gamma = gamma * (3.0 * npart_beta * npart_beta);
        delta = delta * (3.75 * npart_theta * npart_theta);
        T9 = qia * 0.5 * T1;
        gche = beta * T9 * T6;
        noiGd0 = NFINtotal * beta * qia / (1.0 + gche * Rdsi);
        GammaGd0 = gamma * noiGd0;
        sid = 4.0 * Vtm * 1.6021899999999999e-19 * GammaGd0;
        C0 = NFINtotal * coxeff * WeffCV0 * LeffCV;
        if (gamma > 0.0 && delta > 0.0) begin
            sf = (noiGd0 + 1e-15) / sqrt(delta / gamma);
        end
        else begin
            sf = 0.0;
        end
    end
    endcase

    if (RDSMOD != 2) begin
        gspr = 1.0 / Rsource;
        gdpr = 1.0 / Rdrain;
    end
    if (sigvds > 0.0) begin
        I(di,si) <+ devsign * ids;
    end
    else begin
        I(si,di) <+ devsign * ids;
    end
    I(di,si) <+ devsign * ddt(qd);
    I(ge,si) <+ devsign * ddt(qg);
    if (sigvds > 0.0) begin
        I(di,si) <+ devsign * idsgen;
        I(ge,si) <+ devsign * (igcs + igs);
        I(ge,di) <+ devsign * (igcd + igd);
        if (BULKMOD != 0) begin
            I(di,e) <+ devsign * (igidl + Iii);
            I(si,e) <+ devsign * igisl;
            I(ge,e) <+ devsign * (igbinv + igbacc);
        end
        else begin
            I(di,si) <+ devsign * (igidl + Iii);
            I(si,di) <+ devsign * igisl;
        end
    end
    else begin
        I(si,di) <+ devsign * idsgen;
        I(ge,di) <+ devsign * (igcs + igs);
        I(ge,si) <+ devsign * (igcd + igd);
        if (BULKMOD != 0) begin
            I(si,e) <+ devsign * (igidl + Iii);
            I(di,e) <+ devsign * igisl;
            I(ge,e) <+ devsign * (igbinv + igbacc);
        end
        else begin
            I(si,di) <+ devsign * (igidl + Iii);
            I(di,si) <+ devsign * igisl;
        end
    end
    if (BULKMOD == 0) begin
        I(ge,si) <+ devsign * igbs;
        I(ge,di) <+ devsign * igbd;
    end
    if (BULKMOD != 0) begin
        I(e,si) <+ devsign * Ies;
        I(e,di) <+ devsign * Ied;
    end
    I(e,si) <+ devsign * ddt(Qes);
    I(e,di) <+ devsign * ddt(Qed);
    I(e,ge) <+ devsign * ddt(Qeg);
    I(ge,si) <+ ddt(qgs_parasitic);
    I(ge,di) <+ ddt(qgd_parasitic);
    I(d,s) <+ ddt(qds_fr);
    if (CGEOMOD == 1) begin
        I(ge,s) <+ ddt(qgs_fr);
        I(ge,d) <+ ddt(qgd_fr);
    end
    if (BULKMOD != 0) begin
        I(ge,si) <+ devsign * ddt(qg_acc);
        I(e,si) <+ devsign * ddt(qb_acc);
    end
    if (RDSMOD == 2) begin
        V(d,di) <+ 0.0;
        V(s,si) <+ 0.0;
    end
    else begin
        I(d,di) <+ V(d,di) / Rdrain;
        I(s,si) <+ V(s,si) / Rsource;
    end
    if (RGATEMOD != 0) I(g,ge) <+ V(g,ge) * ggeltd;
    else V(g,ge) <+ 0.0;
    I(di,si) <+ flicker_noise(FNPowerAt1Hz,EF,"flicker");
    if (RDSMOD != 2) begin
        I(d,di) <+ white_noise(4.0 * Vtm * 1.6021899999999999e-19 * gdpr,"thermal");
        I(s,si) <+ white_noise(4.0 * Vtm * 1.6021899999999999e-19 * gspr,"thermal");
    end
    if (RGATEMOD != 0) I(g,ge) <+ white_noise(4.0 * Vtm * 1.6021899999999999e-19 * ggeltd,"thermal");
    if (TNOIMOD == 0) begin
        I(di,si) <+ white_noise(sid,"thermal");
        V(N) <+ 0.0;
    end
    else begin
        I(di,si) <+ white_noise(sid * abs(1.0 - ctnoi * ctnoi),"thermal");
        I(di,si) <+ ctnoi * V(N) * sf * SCALEN;
        if (gamma > 0 && delta > 0) begin
            I(N) <+ V(N) * sf * SCALEN;
            I(N) <+ white_noise(sid / (sf * sf * SCALEN * SCALEN));
        end
        else begin
            I(N) <+ V(N);
        end
        I(ge,si) <+ ddt(0.5 * C0 * SCALEN * V(N));
        I(ge,di) <+ ddt(0.5 * C0 * SCALEN * V(N));
    end
    if (IGCMOD != 0) begin
        if (sigvds > 0) begin
            I(ge,si) <+ white_noise(2.0 * 1.6021899999999999e-19 * abs(igcs + igs),"shot");
            I(ge,di) <+ white_noise(2.0 * 1.6021899999999999e-19 * abs(igcd + igd),"shot");
        end
        else begin
            I(ge,di) <+ white_noise(2.0 * 1.6021899999999999e-19 * abs(igcs + igs),"shot");
            I(ge,si) <+ white_noise(2.0 * 1.6021899999999999e-19 * abs(igcd + igd),"shot");
        end
    end
    if (IGBMOD != 0) begin
        if (BULKMOD != 0) begin
            I(ge,e) <+ white_noise(2.0 * 1.6021899999999999e-19 * abs(igbinv + igbacc),"shot");
        end
        else begin
            I(ge,si) <+ white_noise(2.0 * 1.6021899999999999e-19 * abs(igbs),"shot");
            I(ge,di) <+ white_noise(2.0 * 1.6021899999999999e-19 * abs(igbd),"shot");
        end
    end
    if (SHMOD != 0 && RTH0 > 0) begin
        if (RDSMOD != 2) begin
            Pwr(ith_branch) <+ -(devsign * sigvds * V(di,si) * ids + V(d,di) * V(d,di) / Rdrain + V(s,si) * V(s,si) / Rsource);
        end
        else begin
            Pwr(ith_branch) <+ -(devsign * sigvds * V(di,si) * ids);
        end
    end
    Pwr(rth_branch) <+ Temp(rth_branch) * gth;
    Pwr(rth_branch) <+ ddt(Temp(rth_branch) * cth);
    WEFF = Weff0;
    LEFF = Leff;
    WEFFCV = WeffCV0;
    LEFFCV = LeffCV;
    IDS = devsign * ids;
    if (sigvds > 0) begin
        if (BULKMOD != 0) begin
            IDEFF = IDS + devsign * idsgen - devsign * (igd + igcd) + devsign * (Iii + igidl) - devsign * Ied;
            ISEFF = -IDS - devsign * idsgen - devsign * (igs + igcs) + devsign * (igisl) - devsign * Ies;
        end
        else begin
            IDEFF = IDS + devsign * idsgen - devsign * (igd + igcd + igbd) + devsign * (Iii + igidl - igisl);
            ISEFF = -IDS - devsign * idsgen - devsign * (igs + igcs + igbs) + devsign * (igisl - igidl);
        end
    end
    else begin
        if (BULKMOD != 0) begin
            IDEFF = -IDS - devsign * idsgen - devsign * (igs + igcs) + devsign * (igisl) - devsign * Ied;
            ISEFF = IDS + devsign * idsgen - devsign * (igd + igcd) + devsign * (Iii + igidl) - devsign * Ies;
        end
        else begin
            IDEFF = -IDS - devsign * idsgen - devsign * (igs + igcs + igbd) + devsign * (igisl - igidl);
            ISEFF = IDS + devsign * idsgen - devsign * (igd + igcd + igbs) + devsign * (Iii + igidl - igisl);
        end
    end
    if (BULKMOD == 0) begin
        IGTOT = devsign * (igs + igd + igcs + igcd + igbs + igbd);
    end
    else begin
        IGTOT = devsign * (igs + igd + igcs + igcd + igbacc + igbinv);
    end
    IDSGEN = sigvds * devsign * idsgen;
    III = devsign * Iii;
    if (sigvds > 0) begin
        IGIDL = devsign * igidl;
        IGISL = devsign * igisl;
    end
    else begin
        IGIDL = devsign * igisl;
        IGISL = devsign * igidl;
    end
    if (BULKMOD != 0) begin
        IJSB = -devsign * Ies;
        IJDB = -devsign * Ied;
    end
    else begin
        IJSB = 0.0;
        IJDB = 0.0;
    end
    if (BULKMOD != 0) begin
        ISUB = -III - IGIDL - IGISL - IJSB - IJDB - devsign * (igbinv + igbacc);
    end
    else begin
        ISUB = 0.0;
    end
    BETA = beta;
    VDSSAT = Vdsat;
    if (NGATE_i > 0) begin
        _argR296_1_ = NGATE_i / ni;
        begin : llnE296
            real lln;
            real x_f2;

            x_f2 = _argR296_1_;
            lln = ln(max(x_f2,9.9999999999999996e-39));
            llnE296 = lln;
        end
        VFB = -devsign * (phib + Vtm * llnE296);
    end
    else VFB = PHIG_i - (EASUB + 0.5 * Eg + devsign * phib);
    q0 = 10.0 * Vtm / rc + 2.0 * qbs;
    T1 = Vtm * (Vtm + q0);
    T2 = cox * cox * T1;
    T3 = 2.0 * 1.6021899999999999e-19 * ni * epssub * Vtm;
    _argR297_1_ = T2 / T3;
    begin : llnE297
        real lln;
        real x_f2;

        x_f2 = _argR297_1_;
        lln = ln(max(x_f2,9.9999999999999996e-39));
        llnE297 = lln;
    end
    VTH = VFB + devsign * (Vtm * llnE297 + dvch_qm + phib + qbs + Vtm + dvth_all - DELVTRAND);
    $strobe("VTH = %e",VTH);
    GM = ddx(IDS,V(ge));
    GDS = ddx(IDS,V(di));
    if (BULKMOD != 0) GMBS = ddx(IDS,V(e));
    else GMBS = 0.0;
    QGI = devsign * qg + devsign * qg_acc;
    QDI = devsign * qd;
    QSI = devsign * qs;
    QBI = devsign * (qb + qb_acc);
    QG = devsign * qg + qgs_parasitic + qgd_parasitic + ((CGEOMOD == 1)?qgs_fr + qgd_fr:0) + devsign * qg_acc - devsign * Qeg;
    QD = devsign * qd - qgd_parasitic - ((CGEOMOD == 1)?qgd_fr:0) - devsign * Qed;
    QS = devsign * qs - qgs_parasitic - ((CGEOMOD == 1)?qgs_fr:0) - devsign * Qes;
    QB = devsign * (qb + qb_acc) + devsign * (Qeg + Qes + Qed);
    CGGI = ddx(QGI,V(ge));
    CGSI = -ddx(QGI,V(si));
    CGDI = -ddx(QGI,V(di));
    CGEI = -ddx(QGI,V(e));
    CSGI = -ddx(QSI,V(ge));
    CSDI = -ddx(QSI,V(di));
    CSSI = ddx(QSI,V(si));
    CSEI = -ddx(QSI,V(e));
    CDGI = -ddx(QDI,V(ge));
    CDDI = ddx(QDI,V(di));
    CDSI = -ddx(QDI,V(si));
    CDEI = -ddx(QDI,V(e));
    CEGI = -ddx(QBI,V(ge));
    CEDI = -ddx(QBI,V(di));
    CESI = -ddx(QBI,V(si));
    CEEI = ddx(QBI,V(e));
    CGG = ddx(QG,V(ge));
    CGS = -ddx(QG,V(si));
    CGD = -ddx(QG,V(di));
    CGE = -ddx(QG,V(e));
    CSG = -ddx(QS,V(ge));
    CSD = -ddx(QS,V(di));
    CSS = ddx(QS,V(si));
    CSE = -ddx(QS,V(e));
    CDG = -ddx(QD,V(ge));
    CDD = ddx(QD,V(di));
    CDS = -ddx(QD,V(si));
    CDE = -ddx(QD,V(e));
    CEG = -ddx(QB,V(ge));
    CED = -ddx(QB,V(di));
    CES = -ddx(QB,V(si));
    CEE = ddx(QB,V(e));
    CGSEXT = -ddx(qgs_parasitic + ((CGEOMOD == 1)?qgs_fr:0),V(si));
    CGDEXT = -ddx(qgd_parasitic + ((CGEOMOD == 1)?qgd_fr:0),V(di));
    CGBOV = -devsign * ddx(Qeg,V(e));
    CJST = -devsign * ddx(Qes,V(si));
    CJDT = -devsign * ddx(Qed,V(di));
    RSGEO = RSourceGeo;
    RDGEO = RDrainGeo;
    CFGEO = Cfr_geo;
    T_TOTAL_K = DevTemp;
    T_TOTAL_C = DevTemp - 273.15;
    T_DELTA_SH = Temp(t);
    IGS = devsign * igs;
    IGD = devsign * igd;
    IGCS = devsign * igcs;
    IGCD = devsign * igcd;
    if (BULKMOD == 0) begin
        IGBS = devsign * igbs;
        IGBD = devsign * igbd;
    end
    else begin
        IGBINV = devsign * igbinv;
        IGBACC = devsign * igbacc;
    end
    DIDSDVG = devsign * sigvds * ddx(ids,V(ge));
    DIDSDVS = devsign * sigvds * ddx(ids,V(si));
    DIDSDVD = devsign * sigvds * ddx(ids,V(di));
    DIDSDVTH = devsign * sigvds * ddx(ids,Temp(t));
    DIGSDVG = devsign * ddx(igs + igcs,V(ge));
    DIGSDVS = devsign * ddx(igs + igcs,V(si));
    DIGSDVD = devsign * ddx(igs + igcs,V(di));
    DIGSDVTH = devsign * ddx(igs + igcs,Temp(t));
    DIGDDVG = devsign * ddx(igd + igcd,V(ge));
    DIGDDVS = devsign * ddx(igd + igcd,V(si));
    DIGDDVD = devsign * ddx(igd + igcd,V(di));
    DIGDDVTH = devsign * ddx(igd + igcd,Temp(t));
    DIIIDVG = devsign * ddx(Iii,V(ge));
    DIIIDVS = devsign * ddx(Iii,V(si));
    DIIIDVD = devsign * ddx(Iii,V(di));
    DIIIDVTH = devsign * ddx(Iii,Temp(t));
    DIGIDLDVG = devsign * ddx(igidl,V(ge));
    DIGIDLDVS = devsign * ddx(igidl,V(si));
    DIGIDLDVD = devsign * ddx(igidl,V(di));
    DIGIDLDVTH = devsign * ddx(igidl,Temp(t));
    DIGISLDVG = devsign * ddx(igisl,V(ge));
    DIGISLDVS = devsign * ddx(igisl,V(si));
    DIGISLDVD = devsign * ddx(igisl,V(di));
    DIGISLDVTH = devsign * ddx(igisl,Temp(t));
    CGT = ddx(QG,Temp(t));
    CST = ddx(QS,Temp(t));
    CDT = ddx(QD,Temp(t));
    ITH = ids * vds;
    DITHDVTH = ddx(ITH,Temp(t));
    DITHDVG = ddx(ITH,V(ge));
    DITHDVS = ddx(ITH,V(si));
    DITHDVD = ddx(ITH,V(di));
end

endmodule

// Finished pva on Sun Sep 14 19:04:05 2025
